simulator( 'spectre )
design(	 "/afs/ece.cmu.edu/usr/bflores/simulation/l9_testbench/spectre/schematic/netlist/netlist")
resultsDir( "/afs/ece.cmu.edu/usr/bflores/simulation/l9_testbench/spectre/schematic" )
modelFile(
    '("/afs/ece.cmu.edu/class/ece320/F10/gpdk090_v4.5/libs.oa22/gpdk090/../../models/spectre/gpdk090.scs" "NN")
)
analysis('tran ?stop "5n"  )
desVar(	  "lambda" 50n	)
desVar(	  "beta" 2.249	)
temp( 27 )
run()
selectResult( 'tran )
plot(getData("/a") )
delay = delay(VT("/a") 0.6 1 "either" VT("/b") 0.6 1 "either" 0 0 nil nil)
plot( delay ?expr '( "delay" ) )
Rise = delay(VT("/a") 0.12 1 "rising" VT("/a") 1.08 1 "rising" 0 0 nil nil)
plot( Rise ?expr '( "Rise" ) )
Fall = delay(VT("/a") 1.08 1 "falling" VT("/a") 0.12 1 "falling" 0 0 nil nil)
plot( Fall ?expr '( "Fall" ) )

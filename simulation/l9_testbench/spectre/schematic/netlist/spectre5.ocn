simulator( 'spectre )
design(	 "/afs/ece.cmu.edu/usr/bflores/simulation/l9_testbench/spectre/schematic/netlist/netlist")
resultsDir( "/afs/ece.cmu.edu/usr/bflores/simulation/l9_testbench/spectre/schematic" )
modelFile(
    '("/afs/ece.cmu.edu/class/ece320/F10/gpdk090_v4.5/libs.oa22/gpdk090/../../models/spectre/gpdk090.scs" "NN")
)
analysis('tran ?stop "5n"  )
desVar(	  "lambda" 50n	)
desVar(	  "beta" 2	)
temp( 27 )
run()
selectResult( 'tran )
plot(getData("/b") getData("/a") )
Delay = delay(VT("/a") 0.6 1 "either" VT("/b") 0.6 1 "either" 0 0 nil nil)
plot( Delay ?expr '( "Delay" ) )
modelFile(
    '("/afs/ece.cmu.edu/class/ece320/F10/gpdk090_v4.5/libs.oa22/gpdk090/../../models/spectre/gpdk090.scs" "NN")
)
desVar(	  "beta" 1	)
run()
selectResult( 'tran )
plot(getData("/b") getData("/a") )
Delay = delay(VT("/a") 0.6 1 "either" VT("/b") 0.6 1 "either" 0 0 nil nil)
plot( Delay ?expr '( "Delay" ) )
modelFile(
    '("/afs/ece.cmu.edu/class/ece320/F10/gpdk090_v4.5/libs.oa22/gpdk090/../../models/spectre/gpdk090.scs" "NN")
)
desVar(	  "beta" 5	)
run()
selectResult( 'tran )
plot(getData("/b") getData("/a") )
Delay = delay(VT("/a") 0.6 1 "either" VT("/b") 0.6 1 "either" 0 0 nil nil)
plot( Delay ?expr '( "Delay" ) )
modelFile(
    '("/afs/ece.cmu.edu/class/ece320/F10/gpdk090_v4.5/libs.oa22/gpdk090/../../models/spectre/gpdk090.scs" "NN")
)
run()
selectResult( 'tran )
plot(getData("/b") getData("/a") )
Delay = delay(VT("/a") 0.6 1 "either" VT("/b") 0.6 1 "either" 0 0 nil nil)
plot( Delay ?expr '( "Delay" ) )
modelFile(
    '("/afs/ece.cmu.edu/class/ece320/F10/gpdk090_v4.5/libs.oa22/gpdk090/../../models/spectre/gpdk090.scs" "NN")
)
run()
selectResult( 'tran )
plot(getData("/b") getData("/a") )
Delay = delay(VT("/a") 0.6 1 "either" VT("/b") 0.6 1 "either" 0 0 nil nil)
plot( Delay ?expr '( "Delay" ) )
modelFile(
    '("/afs/ece.cmu.edu/class/ece320/F10/gpdk090_v4.5/libs.oa22/gpdk090/../../models/spectre/gpdk090.scs" "NN")
)
desVar(	  "beta" 2	)
run()
selectResult( 'tran )
plot(getData("/b") getData("/a") )
Delay = delay(VT("/a") 0.6 1 "either" VT("/b") 0.6 1 "either" 0 0 nil nil)
plot( Delay ?expr '( "Delay" ) )
modelFile(
    '("/afs/ece.cmu.edu/class/ece320/F10/gpdk090_v4.5/libs.oa22/gpdk090/../../models/spectre/gpdk090.scs" "NN")
)
desVar(	  "beta" 1	)
run()
selectResult( 'tran )
plot(getData("/b") getData("/a") )
Delay = delay(VT("/a") 0.6 1 "either" VT("/b") 0.6 1 "either" 0 0 nil nil)
plot( Delay ?expr '( "Delay" ) )
modelFile(
    '("/afs/ece.cmu.edu/class/ece320/F10/gpdk090_v4.5/libs.oa22/gpdk090/../../models/spectre/gpdk090.scs" "NN")
)
desVar(	  "beta" 15	)
run()
selectResult( 'tran )
plot(getData("/a") getData("/b") )
Rise = delay(VT("/a") 0.12 1 "rising" VT("/a") 1.08 1 "rising" 0 0 nil nil)
plot( Rise ?expr '( "Rise" ) )
Fall = delay(VT("/a") 1.08 1 "falling" VT("/a") 0.12 1 "falling" 0 0 nil nil)
plot( Fall ?expr '( "Fall" ) )
modelFile(
    '("/afs/ece.cmu.edu/class/ece320/F10/gpdk090_v4.5/libs.oa22/gpdk090/../../models/spectre/gpdk090.scs" "NN")
)
desVar(	  "beta" 2	)
run()
selectResult( 'tran )
plot(getData("/a") getData("/b") )
Rise = delay(VT("/a") 0.12 1 "rising" VT("/a") 1.08 1 "rising" 0 0 nil nil)
plot( Rise ?expr '( "Rise" ) )
Fall = delay(VT("/a") 1.08 1 "falling" VT("/a") 0.12 1 "falling" 0 0 nil nil)
plot( Fall ?expr '( "Fall" ) )
modelFile(
    '("/afs/ece.cmu.edu/class/ece320/F10/gpdk090_v4.5/libs.oa22/gpdk090/../../models/spectre/gpdk090.scs" "NN")
)
desVar(	  "beta" 2.5	)
run()
selectResult( 'tran )
plot(getData("/a") getData("/b") )
Rise = delay(VT("/a") 0.12 1 "rising" VT("/a") 1.08 1 "rising" 0 0 nil nil)
plot( Rise ?expr '( "Rise" ) )
Fall = delay(VT("/a") 1.08 1 "falling" VT("/a") 0.12 1 "falling" 0 0 nil nil)
plot( Fall ?expr '( "Fall" ) )
modelFile(
    '("/afs/ece.cmu.edu/class/ece320/F10/gpdk090_v4.5/libs.oa22/gpdk090/../../models/spectre/gpdk090.scs" "NN")
)
desVar(	  "beta" 2.3	)
run()
selectResult( 'tran )
plot(getData("/a") getData("/b") )
Rise = delay(VT("/a") 0.12 1 "rising" VT("/a") 1.08 1 "rising" 0 0 nil nil)
plot( Rise ?expr '( "Rise" ) )
Fall = delay(VT("/a") 1.08 1 "falling" VT("/a") 0.12 1 "falling" 0 0 nil nil)
plot( Fall ?expr '( "Fall" ) )
modelFile(
    '("/afs/ece.cmu.edu/class/ece320/F10/gpdk090_v4.5/libs.oa22/gpdk090/../../models/spectre/gpdk090.scs" "NN")
)
desVar(	  "beta" 2.1	)
run()
selectResult( 'tran )
plot(getData("/a") getData("/b") )
Rise = delay(VT("/a") 0.12 1 "rising" VT("/a") 1.08 1 "rising" 0 0 nil nil)
plot( Rise ?expr '( "Rise" ) )
Fall = delay(VT("/a") 1.08 1 "falling" VT("/a") 0.12 1 "falling" 0 0 nil nil)
plot( Fall ?expr '( "Fall" ) )
modelFile(
    '("/afs/ece.cmu.edu/class/ece320/F10/gpdk090_v4.5/libs.oa22/gpdk090/../../models/spectre/gpdk090.scs" "NN")
)
desVar(	  "beta" 2.15	)
run()
selectResult( 'tran )
plot(getData("/a") getData("/b") )
Rise = delay(VT("/a") 0.12 1 "rising" VT("/a") 1.08 1 "rising" 0 0 nil nil)
plot( Rise ?expr '( "Rise" ) )
Fall = delay(VT("/a") 1.08 1 "falling" VT("/a") 0.12 1 "falling" 0 0 nil nil)
plot( Fall ?expr '( "Fall" ) )
modelFile(
    '("/afs/ece.cmu.edu/class/ece320/F10/gpdk090_v4.5/libs.oa22/gpdk090/../../models/spectre/gpdk090.scs" "NN")
)
desVar(	  "beta" 2.315	)
run()
selectResult( 'tran )
plot(getData("/a") getData("/b") )
Rise = delay(VT("/a") 0.12 1 "rising" VT("/a") 1.08 1 "rising" 0 0 nil nil)
plot( Rise ?expr '( "Rise" ) )
Fall = delay(VT("/a") 1.08 1 "falling" VT("/a") 0.12 1 "falling" 0 0 nil nil)
plot( Fall ?expr '( "Fall" ) )
modelFile(
    '("/afs/ece.cmu.edu/class/ece320/F10/gpdk090_v4.5/libs.oa22/gpdk090/../../models/spectre/gpdk090.scs" "NN")
)
desVar(	  "beta" 2.25	)
run()
selectResult( 'tran )
plot(getData("/a") getData("/b") )
Rise = delay(VT("/a") 0.12 1 "rising" VT("/a") 1.08 1 "rising" 0 0 nil nil)
plot( Rise ?expr '( "Rise" ) )
Fall = delay(VT("/a") 1.08 1 "falling" VT("/a") 0.12 1 "falling" 0 0 nil nil)
plot( Fall ?expr '( "Fall" ) )
modelFile(
    '("/afs/ece.cmu.edu/class/ece320/F10/gpdk090_v4.5/libs.oa22/gpdk090/../../models/spectre/gpdk090.scs" "NN")
)
desVar(	  "beta" 2.24	)
run()
selectResult( 'tran )
plot(getData("/a") getData("/b") )
Rise = delay(VT("/a") 0.12 1 "rising" VT("/a") 1.08 1 "rising" 0 0 nil nil)
plot( Rise ?expr '( "Rise" ) )
Fall = delay(VT("/a") 1.08 1 "falling" VT("/a") 0.12 1 "falling" 0 0 nil nil)
plot( Fall ?expr '( "Fall" ) )
modelFile(
    '("/afs/ece.cmu.edu/class/ece320/F10/gpdk090_v4.5/libs.oa22/gpdk090/../../models/spectre/gpdk090.scs" "NN")
)
desVar(	  "beta" 2.26	)
run()
selectResult( 'tran )
plot(getData("/a") getData("/b") )
Rise = delay(VT("/a") 0.12 1 "rising" VT("/a") 1.08 1 "rising" 0 0 nil nil)
plot( Rise ?expr '( "Rise" ) )
Fall = delay(VT("/a") 1.08 1 "falling" VT("/a") 0.12 1 "falling" 0 0 nil nil)
plot( Fall ?expr '( "Fall" ) )
modelFile(
    '("/afs/ece.cmu.edu/class/ece320/F10/gpdk090_v4.5/libs.oa22/gpdk090/../../models/spectre/gpdk090.scs" "NN")
)
desVar(	  "beta" 2.25	)
run()
selectResult( 'tran )
plot(getData("/a") getData("/b") )
Rise = delay(VT("/a") 0.12 1 "rising" VT("/a") 1.08 1 "rising" 0 0 nil nil)
plot( Rise ?expr '( "Rise" ) )
Fall = delay(VT("/a") 1.08 1 "falling" VT("/a") 0.12 1 "falling" 0 0 nil nil)
plot( Fall ?expr '( "Fall" ) )
modelFile(
    '("/afs/ece.cmu.edu/class/ece320/F10/gpdk090_v4.5/libs.oa22/gpdk090/../../models/spectre/gpdk090.scs" "NN")
)
desVar(	  "beta" 2.251	)
run()
selectResult( 'tran )
plot(getData("/a") getData("/b") )
Rise = delay(VT("/a") 0.12 1 "rising" VT("/a") 1.08 1 "rising" 0 0 nil nil)
plot( Rise ?expr '( "Rise" ) )
Fall = delay(VT("/a") 1.08 1 "falling" VT("/a") 0.12 1 "falling" 0 0 nil nil)
plot( Fall ?expr '( "Fall" ) )
modelFile(
    '("/afs/ece.cmu.edu/class/ece320/F10/gpdk090_v4.5/libs.oa22/gpdk090/../../models/spectre/gpdk090.scs" "NN")
)
desVar(	  "beta" 2.248	)
run()
selectResult( 'tran )
plot(getData("/a") getData("/b") )
Rise = delay(VT("/a") 0.12 1 "rising" VT("/a") 1.08 1 "rising" 0 0 nil nil)
plot( Rise ?expr '( "Rise" ) )
Fall = delay(VT("/a") 1.08 1 "falling" VT("/a") 0.12 1 "falling" 0 0 nil nil)
plot( Fall ?expr '( "Fall" ) )
modelFile(
    '("/afs/ece.cmu.edu/class/ece320/F10/gpdk090_v4.5/libs.oa22/gpdk090/../../models/spectre/gpdk090.scs" "NN")
)
desVar(	  "beta" 2.249	)
run()
selectResult( 'tran )
plot(getData("/a") getData("/b") )
Rise = delay(VT("/a") 0.12 1 "rising" VT("/a") 1.08 1 "rising" 0 0 nil nil)
plot( Rise ?expr '( "Rise" ) )
Fall = delay(VT("/a") 1.08 1 "falling" VT("/a") 0.12 1 "falling" 0 0 nil nil)
plot( Fall ?expr '( "Fall" ) )
modelFile(
    '("/afs/ece.cmu.edu/class/ece320/F10/gpdk090_v4.5/libs.oa22/gpdk090/../../models/spectre/gpdk090.scs" "NN")
)
run()
selectResult( 'tran )
plot(getData("/a") getData("/b") )
delay = delay(VT("/a") 0.6 1 "either" VT("/b") 0.6 1 "either" 0 0 nil nil)
plot( delay ?expr '( "delay" ) )
Rise = delay(VT("/a") 0.12 1 "rising" VT("/a") 1.08 1 "rising" 0 0 nil nil)
plot( Rise ?expr '( "Rise" ) )
Fall = delay(VT("/a") 1.08 1 "falling" VT("/a") 0.12 1 "falling" 0 0 nil nil)
plot( Fall ?expr '( "Fall" ) )
modelFile(
    '("/afs/ece.cmu.edu/class/ece320/F10/gpdk090_v4.5/libs.oa22/gpdk090/../../models/spectre/gpdk090.scs" "NN")
)
run()
selectResult( 'tran )
plot(getData("/a") getData("/b") )
delay = delay(VT("/a") 0.6 1 "either" VT("/b") 0.6 1 "either" 0 0 nil nil)
plot( delay ?expr '( "delay" ) )
Rise = delay(VT("/a") 0.12 1 "rising" VT("/a") 1.08 1 "rising" 0 0 nil nil)
plot( Rise ?expr '( "Rise" ) )
Fall = delay(VT("/a") 1.08 1 "falling" VT("/a") 0.12 1 "falling" 0 0 nil nil)
plot( Fall ?expr '( "Fall" ) )
modelFile(
    '("/afs/ece.cmu.edu/class/ece320/F10/gpdk090_v4.5/libs.oa22/gpdk090/../../models/spectre/gpdk090.scs" "NN")
)
desVar(	  "C_delay" 2	)
run()
selectResult( 'tran )
plot(getData("/a") getData("/b") )
delay = delay(VT("/a") 0.6 1 "either" VT("/b") 0.6 1 "either" 0 0 nil nil)
plot( delay ?expr '( "delay" ) )
Rise = delay(VT("/a") 0.12 1 "rising" VT("/a") 1.08 1 "rising" 0 0 nil nil)
plot( Rise ?expr '( "Rise" ) )
Fall = delay(VT("/a") 1.08 1 "falling" VT("/a") 0.12 1 "falling" 0 0 nil nil)
plot( Fall ?expr '( "Fall" ) )
modelFile(
    '("/afs/ece.cmu.edu/class/ece320/F10/gpdk090_v4.5/libs.oa22/gpdk090/../../models/spectre/gpdk090.scs" "NN")
)
run()
selectResult( 'tran )
plot(getData("/a") getData("/b") )
delay = delay(VT("/a") 0.6 1 "either" VT("/b") 0.6 1 "either" 0 0 nil nil)
plot( delay ?expr '( "delay" ) )
Rise = delay(VT("/a") 0.12 1 "rising" VT("/a") 1.08 1 "rising" 0 0 nil nil)
plot( Rise ?expr '( "Rise" ) )
Fall = delay(VT("/a") 1.08 1 "falling" VT("/a") 0.12 1 "falling" 0 0 nil nil)
plot( Fall ?expr '( "Fall" ) )

simulator( 'spectre )
design(	 "/afs/ece.cmu.edu/usr/bflores/simulation/testbench_1_5/spectre/schematic/netlist/netlist")
resultsDir( "/afs/ece.cmu.edu/usr/bflores/simulation/testbench_1_5/spectre/schematic" )
modelFile(
    '("/afs/ece.cmu.edu/class/ece320/F10/gpdk090_v4.5/libs.oa22/gpdk090/../../models/spectre/gpdk090.scs" "NN")
)
analysis('tran ?stop "5n"  )
desVar(	  "lambda" 50n	)
desVar(	  "C_delay" 4.249	)
desVar(	  "beta" 2.249	)
temp( 27 )
run()
delay_a_b = delay(VT("/a") 0.6 1 "either" VT("/b") 0.6 1 "either" 0 0 nil nil)
plot( delay_a_b ?expr '( "delay_a_b" ) )
delay_a_c = delay(VT("/a") 0.6 1 "either" VT("/c") 0.6 1 "either" 0 0 nil nil)
plot( delay_a_c ?expr '( "delay_a_c" ) )
modelFile(
    '("/afs/ece.cmu.edu/class/ece320/F10/gpdk090_v4.5/libs.oa22/gpdk090/../../models/spectre/gpdk090.scs" "NN")
)
run()
delay_a_b = delay(VT("/a") 0.6 1 "either" VT("/b") 0.6 1 "either" 0 0 nil nil)
plot( delay_a_b ?expr '( "delay_a_b" ) )
delay_a_c = delay(VT("/a") 0.6 1 "either" VT("/c") 0.6 1 "either" 0 0 nil nil)
plot( delay_a_c ?expr '( "delay_a_c" ) )
Rise = delay(VT("/a") 0.12 1 "rising" VT("/a") 1.08 1 "rising" 0 0 nil nil)
plot( Rise ?expr '( "Rise" ) )
Fal\; = delay(VT("/a") 1.08 1 "falling" VT("/a") 0.12 1 "falling" 0 0 nil nil)
plot( Fal\; ?expr '( "Fal;" ) )
modelFile(
    '("/afs/ece.cmu.edu/class/ece320/F10/gpdk090_v4.5/libs.oa22/gpdk090/../../models/spectre/gpdk090.scs" "NN")
)
desVar(	  "beta" 2.5	)
run()
delay_a_b = delay(VT("/a") 0.6 1 "either" VT("/b") 0.6 1 "either" 0 0 nil nil)
plot( delay_a_b ?expr '( "delay_a_b" ) )
delay_a_c = delay(VT("/a") 0.6 1 "either" VT("/c") 0.6 1 "either" 0 0 nil nil)
plot( delay_a_c ?expr '( "delay_a_c" ) )
Rise = delay(VT("/a") 0.12 1 "rising" VT("/a") 1.08 1 "rising" 0 0 nil nil)
plot( Rise ?expr '( "Rise" ) )
Fal\; = delay(VT("/a") 1.08 1 "falling" VT("/a") 0.12 1 "falling" 0 0 nil nil)
plot( Fal\; ?expr '( "Fal;" ) )
modelFile(
    '("/afs/ece.cmu.edu/class/ece320/F10/gpdk090_v4.5/libs.oa22/gpdk090/../../models/spectre/gpdk090.scs" "NN")
)
desVar(	  "beta" 2.4	)
run()
delay_a_b = delay(VT("/a") 0.6 1 "either" VT("/b") 0.6 1 "either" 0 0 nil nil)
plot( delay_a_b ?expr '( "delay_a_b" ) )
delay_a_c = delay(VT("/a") 0.6 1 "either" VT("/c") 0.6 1 "either" 0 0 nil nil)
plot( delay_a_c ?expr '( "delay_a_c" ) )
Rise = delay(VT("/a") 0.12 1 "rising" VT("/a") 1.08 1 "rising" 0 0 nil nil)
plot( Rise ?expr '( "Rise" ) )
Fal\; = delay(VT("/a") 1.08 1 "falling" VT("/a") 0.12 1 "falling" 0 0 nil nil)
plot( Fal\; ?expr '( "Fal;" ) )
modelFile(
    '("/afs/ece.cmu.edu/class/ece320/F10/gpdk090_v4.5/libs.oa22/gpdk090/../../models/spectre/gpdk090.scs" "NN")
)
desVar(	  "beta" 2.48	)
run()
delay_a_b = delay(VT("/a") 0.6 1 "either" VT("/b") 0.6 1 "either" 0 0 nil nil)
plot( delay_a_b ?expr '( "delay_a_b" ) )
delay_a_c = delay(VT("/a") 0.6 1 "either" VT("/c") 0.6 1 "either" 0 0 nil nil)
plot( delay_a_c ?expr '( "delay_a_c" ) )
Rise = delay(VT("/a") 0.12 1 "rising" VT("/a") 1.08 1 "rising" 0 0 nil nil)
plot( Rise ?expr '( "Rise" ) )
Fal\; = delay(VT("/a") 1.08 1 "falling" VT("/a") 0.12 1 "falling" 0 0 nil nil)
plot( Fal\; ?expr '( "Fal;" ) )
modelFile(
    '("/afs/ece.cmu.edu/class/ece320/F10/gpdk090_v4.5/libs.oa22/gpdk090/../../models/spectre/gpdk090.scs" "NN")
)
desVar(	  "beta" 2.6	)
run()
delay_a_b = delay(VT("/a") 0.6 1 "either" VT("/b") 0.6 1 "either" 0 0 nil nil)
plot( delay_a_b ?expr '( "delay_a_b" ) )
delay_a_c = delay(VT("/a") 0.6 1 "either" VT("/c") 0.6 1 "either" 0 0 nil nil)
plot( delay_a_c ?expr '( "delay_a_c" ) )
Rise = delay(VT("/a") 0.12 1 "rising" VT("/a") 1.08 1 "rising" 0 0 nil nil)
plot( Rise ?expr '( "Rise" ) )
Fal\; = delay(VT("/a") 1.08 1 "falling" VT("/a") 0.12 1 "falling" 0 0 nil nil)
plot( Fal\; ?expr '( "Fal;" ) )
modelFile(
    '("/afs/ece.cmu.edu/class/ece320/F10/gpdk090_v4.5/libs.oa22/gpdk090/../../models/spectre/gpdk090.scs" "NN")
)
desVar(	  "beta" 2.4	)
run()
delay_a_b = delay(VT("/a") 0.6 1 "either" VT("/b") 0.6 1 "either" 0 0 nil nil)
plot( delay_a_b ?expr '( "delay_a_b" ) )
delay_a_c = delay(VT("/a") 0.6 1 "either" VT("/c") 0.6 1 "either" 0 0 nil nil)
plot( delay_a_c ?expr '( "delay_a_c" ) )
Rise = delay(VT("/a") 0.12 1 "rising" VT("/a") 1.08 1 "rising" 0 0 nil nil)
plot( Rise ?expr '( "Rise" ) )
Fal\; = delay(VT("/a") 1.08 1 "falling" VT("/a") 0.12 1 "falling" 0 0 nil nil)
plot( Fal\; ?expr '( "Fal;" ) )
modelFile(
    '("/afs/ece.cmu.edu/class/ece320/F10/gpdk090_v4.5/libs.oa22/gpdk090/../../models/spectre/gpdk090.scs" "NN")
)
run()
delay_a_b = delay(VT("/a") 0.6 1 "either" VT("/b") 0.6 1 "either" 0 0 nil nil)
plot( delay_a_b ?expr '( "delay_a_b" ) )
delay_a_c = delay(VT("/a") 0.6 1 "either" VT("/c") 0.6 1 "either" 0 0 nil nil)
plot( delay_a_c ?expr '( "delay_a_c" ) )
Rise = delay(VT("/a") 0.12 1 "rising" VT("/a") 1.08 1 "rising" 0 0 nil nil)
plot( Rise ?expr '( "Rise" ) )
Fall = delay(VT("/a") 1.08 1 "falling" VT("/a") 0.12 1 "falling" 0 0 nil nil)
plot( Fall ?expr '( "Fall" ) )
diff = (delay(VT("/a") 0.12 1 "rising" VT("/a") 1.08 1 "rising" 0 0 nil nil) - delay(VT("/a") 1.08 1 "falling" VT("/a") 0.12 1 "falling" 0 0 nil nil))
plot( diff ?expr '( "diff" ) )
modelFile(
    '("/afs/ece.cmu.edu/class/ece320/F10/gpdk090_v4.5/libs.oa22/gpdk090/../../models/spectre/gpdk090.scs" "NN")
)
desVar(	  "beta" 2.7	)
run()
delay_a_b = delay(VT("/a") 0.6 1 "either" VT("/b") 0.6 1 "either" 0 0 nil nil)
plot( delay_a_b ?expr '( "delay_a_b" ) )
delay_a_c = delay(VT("/a") 0.6 1 "either" VT("/c") 0.6 1 "either" 0 0 nil nil)
plot( delay_a_c ?expr '( "delay_a_c" ) )
Rise = delay(VT("/a") 0.12 1 "rising" VT("/a") 1.08 1 "rising" 0 0 nil nil)
plot( Rise ?expr '( "Rise" ) )
Fall = delay(VT("/a") 1.08 1 "falling" VT("/a") 0.12 1 "falling" 0 0 nil nil)
plot( Fall ?expr '( "Fall" ) )
diff = (delay(VT("/a") 0.12 1 "rising" VT("/a") 1.08 1 "rising" 0 0 nil nil) - delay(VT("/a") 1.08 1 "falling" VT("/a") 0.12 1 "falling" 0 0 nil nil))
plot( diff ?expr '( "diff" ) )
modelFile(
    '("/afs/ece.cmu.edu/class/ece320/F10/gpdk090_v4.5/libs.oa22/gpdk090/../../models/spectre/gpdk090.scs" "NN")
)
desVar(	  "beta" 2.2	)
run()
delay_a_b = delay(VT("/a") 0.6 1 "either" VT("/b") 0.6 1 "either" 0 0 nil nil)
plot( delay_a_b ?expr '( "delay_a_b" ) )
delay_a_c = delay(VT("/a") 0.6 1 "either" VT("/c") 0.6 1 "either" 0 0 nil nil)
plot( delay_a_c ?expr '( "delay_a_c" ) )
Rise = delay(VT("/a") 0.12 1 "rising" VT("/a") 1.08 1 "rising" 0 0 nil nil)
plot( Rise ?expr '( "Rise" ) )
Fall = delay(VT("/a") 1.08 1 "falling" VT("/a") 0.12 1 "falling" 0 0 nil nil)
plot( Fall ?expr '( "Fall" ) )
diff = (delay(VT("/a") 0.12 1 "rising" VT("/a") 1.08 1 "rising" 0 0 nil nil) - delay(VT("/a") 1.08 1 "falling" VT("/a") 0.12 1 "falling" 0 0 nil nil))
plot( diff ?expr '( "diff" ) )
modelFile(
    '("/afs/ece.cmu.edu/class/ece320/F10/gpdk090_v4.5/libs.oa22/gpdk090/../../models/spectre/gpdk090.scs" "NN")
)
desVar(	  "beta" 1.9	)
run()
delay_a_b = delay(VT("/a") 0.6 1 "either" VT("/b") 0.6 1 "either" 0 0 nil nil)
plot( delay_a_b ?expr '( "delay_a_b" ) )
delay_a_c = delay(VT("/a") 0.6 1 "either" VT("/c") 0.6 1 "either" 0 0 nil nil)
plot( delay_a_c ?expr '( "delay_a_c" ) )
Rise = delay(VT("/a") 0.12 1 "rising" VT("/a") 1.08 1 "rising" 0 0 nil nil)
plot( Rise ?expr '( "Rise" ) )
Fall = delay(VT("/a") 1.08 1 "falling" VT("/a") 0.12 1 "falling" 0 0 nil nil)
plot( Fall ?expr '( "Fall" ) )
diff = (delay(VT("/a") 0.12 1 "rising" VT("/a") 1.08 1 "rising" 0 0 nil nil) - delay(VT("/a") 1.08 1 "falling" VT("/a") 0.12 1 "falling" 0 0 nil nil))
plot( diff ?expr '( "diff" ) )
modelFile(
    '("/afs/ece.cmu.edu/class/ece320/F10/gpdk090_v4.5/libs.oa22/gpdk090/../../models/spectre/gpdk090.scs" "NN")
)
desVar(	  "beta" 2	)
run()
delay_a_b = delay(VT("/a") 0.6 1 "either" VT("/b") 0.6 1 "either" 0 0 nil nil)
plot( delay_a_b ?expr '( "delay_a_b" ) )
delay_a_c = delay(VT("/a") 0.6 1 "either" VT("/c") 0.6 1 "either" 0 0 nil nil)
plot( delay_a_c ?expr '( "delay_a_c" ) )
Rise = delay(VT("/a") 0.12 1 "rising" VT("/a") 1.08 1 "rising" 0 0 nil nil)
plot( Rise ?expr '( "Rise" ) )
Fall = delay(VT("/a") 1.08 1 "falling" VT("/a") 0.12 1 "falling" 0 0 nil nil)
plot( Fall ?expr '( "Fall" ) )
diff = (delay(VT("/a") 0.12 1 "rising" VT("/a") 1.08 1 "rising" 0 0 nil nil) - delay(VT("/a") 1.08 1 "falling" VT("/a") 0.12 1 "falling" 0 0 nil nil))
plot( diff ?expr '( "diff" ) )
modelFile(
    '("/afs/ece.cmu.edu/class/ece320/F10/gpdk090_v4.5/libs.oa22/gpdk090/../../models/spectre/gpdk090.scs" "NN")
)
desVar(	  "beta" 2.5	)
run()
delay_a_b = delay(VT("/a") 0.6 1 "either" VT("/b") 0.6 1 "either" 0 0 nil nil)
plot( delay_a_b ?expr '( "delay_a_b" ) )
delay_a_c = delay(VT("/a") 0.6 1 "either" VT("/c") 0.6 1 "either" 0 0 nil nil)
plot( delay_a_c ?expr '( "delay_a_c" ) )
Rise = delay(VT("/a") 0.12 1 "rising" VT("/a") 1.08 1 "rising" 0 0 nil nil)
plot( Rise ?expr '( "Rise" ) )
Fall = delay(VT("/a") 1.08 1 "falling" VT("/a") 0.12 1 "falling" 0 0 nil nil)
plot( Fall ?expr '( "Fall" ) )
diff = (delay(VT("/a") 0.12 1 "rising" VT("/a") 1.08 1 "rising" 0 0 nil nil) - delay(VT("/a") 1.08 1 "falling" VT("/a") 0.12 1 "falling" 0 0 nil nil))
plot( diff ?expr '( "diff" ) )
modelFile(
    '("/afs/ece.cmu.edu/class/ece320/F10/gpdk090_v4.5/libs.oa22/gpdk090/../../models/spectre/gpdk090.scs" "NN")
)
desVar(	  "beta" 2.15	)
run()
delay_a_b = delay(VT("/a") 0.6 1 "either" VT("/b") 0.6 1 "either" 0 0 nil nil)
plot( delay_a_b ?expr '( "delay_a_b" ) )
delay_a_c = delay(VT("/a") 0.6 1 "either" VT("/c") 0.6 1 "either" 0 0 nil nil)
plot( delay_a_c ?expr '( "delay_a_c" ) )
Rise = delay(VT("/a") 0.12 1 "rising" VT("/a") 1.08 1 "rising" 0 0 nil nil)
plot( Rise ?expr '( "Rise" ) )
Fall = delay(VT("/a") 1.08 1 "falling" VT("/a") 0.12 1 "falling" 0 0 nil nil)
plot( Fall ?expr '( "Fall" ) )
diff = (delay(VT("/a") 0.12 1 "rising" VT("/a") 1.08 1 "rising" 0 0 nil nil) - delay(VT("/a") 1.08 1 "falling" VT("/a") 0.12 1 "falling" 0 0 nil nil))
plot( diff ?expr '( "diff" ) )
modelFile(
    '("/afs/ece.cmu.edu/class/ece320/F10/gpdk090_v4.5/libs.oa22/gpdk090/../../models/spectre/gpdk090.scs" "NN")
)
desVar(	  "beta" 2.16	)
run()
delay_a_b = delay(VT("/a") 0.6 1 "either" VT("/b") 0.6 1 "either" 0 0 nil nil)
plot( delay_a_b ?expr '( "delay_a_b" ) )
delay_a_c = delay(VT("/a") 0.6 1 "either" VT("/c") 0.6 1 "either" 0 0 nil nil)
plot( delay_a_c ?expr '( "delay_a_c" ) )
Rise = delay(VT("/a") 0.12 1 "rising" VT("/a") 1.08 1 "rising" 0 0 nil nil)
plot( Rise ?expr '( "Rise" ) )
Fall = delay(VT("/a") 1.08 1 "falling" VT("/a") 0.12 1 "falling" 0 0 nil nil)
plot( Fall ?expr '( "Fall" ) )
diff = (delay(VT("/a") 0.12 1 "rising" VT("/a") 1.08 1 "rising" 0 0 nil nil) - delay(VT("/a") 1.08 1 "falling" VT("/a") 0.12 1 "falling" 0 0 nil nil))
plot( diff ?expr '( "diff" ) )
modelFile(
    '("/afs/ece.cmu.edu/class/ece320/F10/gpdk090_v4.5/libs.oa22/gpdk090/../../models/spectre/gpdk090.scs" "NN")
)
desVar(	  "beta" 2.17	)
run()
delay_a_b = delay(VT("/a") 0.6 1 "either" VT("/b") 0.6 1 "either" 0 0 nil nil)
plot( delay_a_b ?expr '( "delay_a_b" ) )
delay_a_c = delay(VT("/a") 0.6 1 "either" VT("/c") 0.6 1 "either" 0 0 nil nil)
plot( delay_a_c ?expr '( "delay_a_c" ) )
Rise = delay(VT("/a") 0.12 1 "rising" VT("/a") 1.08 1 "rising" 0 0 nil nil)
plot( Rise ?expr '( "Rise" ) )
Fall = delay(VT("/a") 1.08 1 "falling" VT("/a") 0.12 1 "falling" 0 0 nil nil)
plot( Fall ?expr '( "Fall" ) )
diff = (delay(VT("/a") 0.12 1 "rising" VT("/a") 1.08 1 "rising" 0 0 nil nil) - delay(VT("/a") 1.08 1 "falling" VT("/a") 0.12 1 "falling" 0 0 nil nil))
plot( diff ?expr '( "diff" ) )
modelFile(
    '("/afs/ece.cmu.edu/class/ece320/F10/gpdk090_v4.5/libs.oa22/gpdk090/../../models/spectre/gpdk090.scs" "NN")
)
desVar(	  "beta" 2.18	)
run()
delay_a_b = delay(VT("/a") 0.6 1 "either" VT("/b") 0.6 1 "either" 0 0 nil nil)
plot( delay_a_b ?expr '( "delay_a_b" ) )
delay_a_c = delay(VT("/a") 0.6 1 "either" VT("/c") 0.6 1 "either" 0 0 nil nil)
plot( delay_a_c ?expr '( "delay_a_c" ) )
Rise = delay(VT("/a") 0.12 1 "rising" VT("/a") 1.08 1 "rising" 0 0 nil nil)
plot( Rise ?expr '( "Rise" ) )
Fall = delay(VT("/a") 1.08 1 "falling" VT("/a") 0.12 1 "falling" 0 0 nil nil)
plot( Fall ?expr '( "Fall" ) )
diff = (delay(VT("/a") 0.12 1 "rising" VT("/a") 1.08 1 "rising" 0 0 nil nil) - delay(VT("/a") 1.08 1 "falling" VT("/a") 0.12 1 "falling" 0 0 nil nil))
plot( diff ?expr '( "diff" ) )
modelFile(
    '("/afs/ece.cmu.edu/class/ece320/F10/gpdk090_v4.5/libs.oa22/gpdk090/../../models/spectre/gpdk090.scs" "NN")
)
desVar(	  "beta" 2.189	)
run()
delay_a_b = delay(VT("/a") 0.6 1 "either" VT("/b") 0.6 1 "either" 0 0 nil nil)
plot( delay_a_b ?expr '( "delay_a_b" ) )
delay_a_c = delay(VT("/a") 0.6 1 "either" VT("/c") 0.6 1 "either" 0 0 nil nil)
plot( delay_a_c ?expr '( "delay_a_c" ) )
Rise = delay(VT("/a") 0.12 1 "rising" VT("/a") 1.08 1 "rising" 0 0 nil nil)
plot( Rise ?expr '( "Rise" ) )
Fall = delay(VT("/a") 1.08 1 "falling" VT("/a") 0.12 1 "falling" 0 0 nil nil)
plot( Fall ?expr '( "Fall" ) )
diff = (delay(VT("/a") 0.12 1 "rising" VT("/a") 1.08 1 "rising" 0 0 nil nil) - delay(VT("/a") 1.08 1 "falling" VT("/a") 0.12 1 "falling" 0 0 nil nil))
plot( diff ?expr '( "diff" ) )
modelFile(
    '("/afs/ece.cmu.edu/class/ece320/F10/gpdk090_v4.5/libs.oa22/gpdk090/../../models/spectre/gpdk090.scs" "NN")
)
desVar(	  "beta" 2.19	)
run()
delay_a_b = delay(VT("/a") 0.6 1 "either" VT("/b") 0.6 1 "either" 0 0 nil nil)
plot( delay_a_b ?expr '( "delay_a_b" ) )
delay_a_c = delay(VT("/a") 0.6 1 "either" VT("/c") 0.6 1 "either" 0 0 nil nil)
plot( delay_a_c ?expr '( "delay_a_c" ) )
Rise = delay(VT("/a") 0.12 1 "rising" VT("/a") 1.08 1 "rising" 0 0 nil nil)
plot( Rise ?expr '( "Rise" ) )
Fall = delay(VT("/a") 1.08 1 "falling" VT("/a") 0.12 1 "falling" 0 0 nil nil)
plot( Fall ?expr '( "Fall" ) )
diff = (delay(VT("/a") 0.12 1 "rising" VT("/a") 1.08 1 "rising" 0 0 nil nil) - delay(VT("/a") 1.08 1 "falling" VT("/a") 0.12 1 "falling" 0 0 nil nil))
plot( diff ?expr '( "diff" ) )
modelFile(
    '("/afs/ece.cmu.edu/class/ece320/F10/gpdk090_v4.5/libs.oa22/gpdk090/../../models/spectre/gpdk090.scs" "NN")
)
desVar(	  "beta" 2.2	)
run()
delay_a_b = delay(VT("/a") 0.6 1 "either" VT("/b") 0.6 1 "either" 0 0 nil nil)
plot( delay_a_b ?expr '( "delay_a_b" ) )
delay_a_c = delay(VT("/a") 0.6 1 "either" VT("/c") 0.6 1 "either" 0 0 nil nil)
plot( delay_a_c ?expr '( "delay_a_c" ) )
Rise = delay(VT("/a") 0.12 1 "rising" VT("/a") 1.08 1 "rising" 0 0 nil nil)
plot( Rise ?expr '( "Rise" ) )
Fall = delay(VT("/a") 1.08 1 "falling" VT("/a") 0.12 1 "falling" 0 0 nil nil)
plot( Fall ?expr '( "Fall" ) )
diff = (delay(VT("/a") 0.12 1 "rising" VT("/a") 1.08 1 "rising" 0 0 nil nil) - delay(VT("/a") 1.08 1 "falling" VT("/a") 0.12 1 "falling" 0 0 nil nil))
plot( diff ?expr '( "diff" ) )
modelFile(
    '("/afs/ece.cmu.edu/class/ece320/F10/gpdk090_v4.5/libs.oa22/gpdk090/../../models/spectre/gpdk090.scs" "NN")
)
desVar(	  "C_delay" 2	)
run()
delay_a_b = delay(VT("/a") 0.6 1 "either" VT("/b") 0.6 1 "either" 0 0 nil nil)
plot( delay_a_b ?expr '( "delay_a_b" ) )
delay_a_c = delay(VT("/a") 0.6 1 "either" VT("/c") 0.6 1 "either" 0 0 nil nil)
plot( delay_a_c ?expr '( "delay_a_c" ) )
Rise = delay(VT("/a") 0.12 1 "rising" VT("/a") 1.08 1 "rising" 0 0 nil nil)
plot( Rise ?expr '( "Rise" ) )
Fall = delay(VT("/a") 1.08 1 "falling" VT("/a") 0.12 1 "falling" 0 0 nil nil)
plot( Fall ?expr '( "Fall" ) )
diff = (delay(VT("/a") 0.12 1 "rising" VT("/a") 1.08 1 "rising" 0 0 nil nil) - delay(VT("/a") 1.08 1 "falling" VT("/a") 0.12 1 "falling" 0 0 nil nil))
plot( diff ?expr '( "diff" ) )
modelFile(
    '("/afs/ece.cmu.edu/class/ece320/F10/gpdk090_v4.5/libs.oa22/gpdk090/../../models/spectre/gpdk090.scs" "NN")
)
desVar(	  "C_delay" 1.2	)
run()
delay_a_b = delay(VT("/a") 0.6 1 "either" VT("/b") 0.6 1 "either" 0 0 nil nil)
plot( delay_a_b ?expr '( "delay_a_b" ) )
delay_a_c = delay(VT("/a") 0.6 1 "either" VT("/c") 0.6 1 "either" 0 0 nil nil)
plot( delay_a_c ?expr '( "delay_a_c" ) )
Rise = delay(VT("/a") 0.12 1 "rising" VT("/a") 1.08 1 "rising" 0 0 nil nil)
plot( Rise ?expr '( "Rise" ) )
Fall = delay(VT("/a") 1.08 1 "falling" VT("/a") 0.12 1 "falling" 0 0 nil nil)
plot( Fall ?expr '( "Fall" ) )
diff = (delay(VT("/a") 0.12 1 "rising" VT("/a") 1.08 1 "rising" 0 0 nil nil) - delay(VT("/a") 1.08 1 "falling" VT("/a") 0.12 1 "falling" 0 0 nil nil))
plot( diff ?expr '( "diff" ) )
modelFile(
    '("/afs/ece.cmu.edu/class/ece320/F10/gpdk090_v4.5/libs.oa22/gpdk090/../../models/spectre/gpdk090.scs" "NN")
)
desVar(	  "C_delay" 4.449	)
run()
delay_a_b = delay(VT("/a") 0.6 1 "either" VT("/b") 0.6 1 "either" 0 0 nil nil)
plot( delay_a_b ?expr '( "delay_a_b" ) )
delay_a_c = delay(VT("/a") 0.6 1 "either" VT("/c") 0.6 1 "either" 0 0 nil nil)
plot( delay_a_c ?expr '( "delay_a_c" ) )
Rise = delay(VT("/a") 0.12 1 "rising" VT("/a") 1.08 1 "rising" 0 0 nil nil)
plot( Rise ?expr '( "Rise" ) )
Fall = delay(VT("/a") 1.08 1 "falling" VT("/a") 0.12 1 "falling" 0 0 nil nil)
plot( Fall ?expr '( "Fall" ) )
diff = (delay(VT("/a") 0.12 1 "rising" VT("/a") 1.08 1 "rising" 0 0 nil nil) - delay(VT("/a") 1.08 1 "falling" VT("/a") 0.12 1 "falling" 0 0 nil nil))
plot( diff ?expr '( "diff" ) )
modelFile(
    '("/afs/ece.cmu.edu/class/ece320/F10/gpdk090_v4.5/libs.oa22/gpdk090/../../models/spectre/gpdk090.scs" "NN")
)
run()
delay_a_b = delay(VT("/a") 0.6 1 "either" VT("/b") 0.6 1 "either" 0 0 nil nil)
plot( delay_a_b ?expr '( "delay_a_b" ) )
delay_a_c = delay(VT("/a") 0.6 1 "either" VT("/c") 0.6 1 "either" 0 0 nil nil)
plot( delay_a_c ?expr '( "delay_a_c" ) )
Rise = delay(VT("/a") 0.12 1 "rising" VT("/a") 1.08 1 "rising" 0 0 nil nil)
plot( Rise ?expr '( "Rise" ) )
Fall = delay(VT("/a") 1.08 1 "falling" VT("/a") 0.12 1 "falling" 0 0 nil nil)
plot( Fall ?expr '( "Fall" ) )
diff = (delay(VT("/a") 0.12 1 "rising" VT("/a") 1.08 1 "rising" 0 0 nil nil) - delay(VT("/a") 1.08 1 "falling" VT("/a") 0.12 1 "falling" 0 0 nil nil))
plot( diff ?expr '( "diff" ) )
modelFile(
    '("/afs/ece.cmu.edu/class/ece320/F10/gpdk090_v4.5/libs.oa22/gpdk090/../../models/spectre/gpdk090.scs" "NN")
)
desVar(	  "C_delay" 4.2	)
run()
delay_a_b = delay(VT("/a") 0.6 1 "either" VT("/b") 0.6 1 "either" 0 0 nil nil)
plot( delay_a_b ?expr '( "delay_a_b" ) )
delay_a_c = delay(VT("/a") 0.6 1 "either" VT("/c") 0.6 1 "either" 0 0 nil nil)
plot( delay_a_c ?expr '( "delay_a_c" ) )
Rise = delay(VT("/a") 0.12 1 "rising" VT("/a") 1.08 1 "rising" 0 0 nil nil)
plot( Rise ?expr '( "Rise" ) )
Fall = delay(VT("/a") 1.08 1 "falling" VT("/a") 0.12 1 "falling" 0 0 nil nil)
plot( Fall ?expr '( "Fall" ) )
diff = (delay(VT("/a") 0.12 1 "rising" VT("/a") 1.08 1 "rising" 0 0 nil nil) - delay(VT("/a") 1.08 1 "falling" VT("/a") 0.12 1 "falling" 0 0 nil nil))
plot( diff ?expr '( "diff" ) )
modelFile(
    '("/afs/ece.cmu.edu/class/ece320/F10/gpdk090_v4.5/libs.oa22/gpdk090/../../models/spectre/gpdk090.scs" "NN")
)
desVar(	  "C_delay" 6	)
run()
delay_a_b = delay(VT("/a") 0.6 1 "either" VT("/b") 0.6 1 "either" 0 0 nil nil)
plot( delay_a_b ?expr '( "delay_a_b" ) )
delay_a_c = delay(VT("/a") 0.6 1 "either" VT("/c") 0.6 1 "either" 0 0 nil nil)
plot( delay_a_c ?expr '( "delay_a_c" ) )
Rise = delay(VT("/a") 0.12 1 "rising" VT("/a") 1.08 1 "rising" 0 0 nil nil)
plot( Rise ?expr '( "Rise" ) )
Fall = delay(VT("/a") 1.08 1 "falling" VT("/a") 0.12 1 "falling" 0 0 nil nil)
plot( Fall ?expr '( "Fall" ) )
diff = (delay(VT("/a") 0.12 1 "rising" VT("/a") 1.08 1 "rising" 0 0 nil nil) - delay(VT("/a") 1.08 1 "falling" VT("/a") 0.12 1 "falling" 0 0 nil nil))
plot( diff ?expr '( "diff" ) )
modelFile(
    '("/afs/ece.cmu.edu/class/ece320/F10/gpdk090_v4.5/libs.oa22/gpdk090/../../models/spectre/gpdk090.scs" "NN")
)
desVar(	  "C_delay" 1.2	)
run()
delay_a_b = delay(VT("/a") 0.6 1 "either" VT("/b") 0.6 1 "either" 0 0 nil nil)
plot( delay_a_b ?expr '( "delay_a_b" ) )
delay_a_c = delay(VT("/a") 0.6 1 "either" VT("/c") 0.6 1 "either" 0 0 nil nil)
plot( delay_a_c ?expr '( "delay_a_c" ) )
Rise = delay(VT("/a") 0.12 1 "rising" VT("/a") 1.08 1 "rising" 0 0 nil nil)
plot( Rise ?expr '( "Rise" ) )
Fall = delay(VT("/a") 1.08 1 "falling" VT("/a") 0.12 1 "falling" 0 0 nil nil)
plot( Fall ?expr '( "Fall" ) )
diff = (delay(VT("/a") 0.12 1 "rising" VT("/a") 1.08 1 "rising" 0 0 nil nil) - delay(VT("/a") 1.08 1 "falling" VT("/a") 0.12 1 "falling" 0 0 nil nil))
plot( diff ?expr '( "diff" ) )
modelFile(
    '("/afs/ece.cmu.edu/class/ece320/F10/gpdk090_v4.5/libs.oa22/gpdk090/../../models/spectre/gpdk090.scs" "NN")
)
desVar(	  "C_delay" 1.9	)
run()
delay_a_b = delay(VT("/a") 0.6 1 "either" VT("/b") 0.6 1 "either" 0 0 nil nil)
plot( delay_a_b ?expr '( "delay_a_b" ) )
delay_a_c = delay(VT("/a") 0.6 1 "either" VT("/c") 0.6 1 "either" 0 0 nil nil)
plot( delay_a_c ?expr '( "delay_a_c" ) )
Rise = delay(VT("/a") 0.12 1 "rising" VT("/a") 1.08 1 "rising" 0 0 nil nil)
plot( Rise ?expr '( "Rise" ) )
Fall = delay(VT("/a") 1.08 1 "falling" VT("/a") 0.12 1 "falling" 0 0 nil nil)
plot( Fall ?expr '( "Fall" ) )
diff = (delay(VT("/a") 0.12 1 "rising" VT("/a") 1.08 1 "rising" 0 0 nil nil) - delay(VT("/a") 1.08 1 "falling" VT("/a") 0.12 1 "falling" 0 0 nil nil))
plot( diff ?expr '( "diff" ) )
modelFile(
    '("/afs/ece.cmu.edu/class/ece320/F10/gpdk090_v4.5/libs.oa22/gpdk090/../../models/spectre/gpdk090.scs" "NN")
)
desVar(	  "C_delay" 0.25	)
run()
delay_a_b = delay(VT("/a") 0.6 1 "either" VT("/b") 0.6 1 "either" 0 0 nil nil)
plot( delay_a_b ?expr '( "delay_a_b" ) )
delay_a_c = delay(VT("/a") 0.6 1 "either" VT("/c") 0.6 1 "either" 0 0 nil nil)
plot( delay_a_c ?expr '( "delay_a_c" ) )
Rise = delay(VT("/a") 0.12 1 "rising" VT("/a") 1.08 1 "rising" 0 0 nil nil)
plot( Rise ?expr '( "Rise" ) )
Fall = delay(VT("/a") 1.08 1 "falling" VT("/a") 0.12 1 "falling" 0 0 nil nil)
plot( Fall ?expr '( "Fall" ) )
diff = (delay(VT("/a") 0.12 1 "rising" VT("/a") 1.08 1 "rising" 0 0 nil nil) - delay(VT("/a") 1.08 1 "falling" VT("/a") 0.12 1 "falling" 0 0 nil nil))
plot( diff ?expr '( "diff" ) )
modelFile(
    '("/afs/ece.cmu.edu/class/ece320/F10/gpdk090_v4.5/libs.oa22/gpdk090/../../models/spectre/gpdk090.scs" "NN")
)
desVar(	  "C_delay" 0.75	)
run()
delay_a_b = delay(VT("/a") 0.6 1 "either" VT("/b") 0.6 1 "either" 0 0 nil nil)
plot( delay_a_b ?expr '( "delay_a_b" ) )
delay_a_c = delay(VT("/a") 0.6 1 "either" VT("/c") 0.6 1 "either" 0 0 nil nil)
plot( delay_a_c ?expr '( "delay_a_c" ) )
Rise = delay(VT("/a") 0.12 1 "rising" VT("/a") 1.08 1 "rising" 0 0 nil nil)
plot( Rise ?expr '( "Rise" ) )
Fall = delay(VT("/a") 1.08 1 "falling" VT("/a") 0.12 1 "falling" 0 0 nil nil)
plot( Fall ?expr '( "Fall" ) )
diff = (delay(VT("/a") 0.12 1 "rising" VT("/a") 1.08 1 "rising" 0 0 nil nil) - delay(VT("/a") 1.08 1 "falling" VT("/a") 0.12 1 "falling" 0 0 nil nil))
plot( diff ?expr '( "diff" ) )
modelFile(
    '("/afs/ece.cmu.edu/class/ece320/F10/gpdk090_v4.5/libs.oa22/gpdk090/../../models/spectre/gpdk090.scs" "NN")
)
desVar(	  "C_delay" 0.70	)
run()
delay_a_b = delay(VT("/a") 0.6 1 "either" VT("/b") 0.6 1 "either" 0 0 nil nil)
plot( delay_a_b ?expr '( "delay_a_b" ) )
delay_a_c = delay(VT("/a") 0.6 1 "either" VT("/c") 0.6 1 "either" 0 0 nil nil)
plot( delay_a_c ?expr '( "delay_a_c" ) )
Rise = delay(VT("/a") 0.12 1 "rising" VT("/a") 1.08 1 "rising" 0 0 nil nil)
plot( Rise ?expr '( "Rise" ) )
Fall = delay(VT("/a") 1.08 1 "falling" VT("/a") 0.12 1 "falling" 0 0 nil nil)
plot( Fall ?expr '( "Fall" ) )
diff = (delay(VT("/a") 0.12 1 "rising" VT("/a") 1.08 1 "rising" 0 0 nil nil) - delay(VT("/a") 1.08 1 "falling" VT("/a") 0.12 1 "falling" 0 0 nil nil))
plot( diff ?expr '( "diff" ) )
modelFile(
    '("/afs/ece.cmu.edu/class/ece320/F10/gpdk090_v4.5/libs.oa22/gpdk090/../../models/spectre/gpdk090.scs" "NN")
)
desVar(	  "C_delay" 0.55	)
run()
delay_a_b = delay(VT("/a") 0.6 1 "either" VT("/b") 0.6 1 "either" 0 0 nil nil)
plot( delay_a_b ?expr '( "delay_a_b" ) )
delay_a_c = delay(VT("/a") 0.6 1 "either" VT("/c") 0.6 1 "either" 0 0 nil nil)
plot( delay_a_c ?expr '( "delay_a_c" ) )
Rise = delay(VT("/a") 0.12 1 "rising" VT("/a") 1.08 1 "rising" 0 0 nil nil)
plot( Rise ?expr '( "Rise" ) )
Fall = delay(VT("/a") 1.08 1 "falling" VT("/a") 0.12 1 "falling" 0 0 nil nil)
plot( Fall ?expr '( "Fall" ) )
diff = (delay(VT("/a") 0.12 1 "rising" VT("/a") 1.08 1 "rising" 0 0 nil nil) - delay(VT("/a") 1.08 1 "falling" VT("/a") 0.12 1 "falling" 0 0 nil nil))
plot( diff ?expr '( "diff" ) )
modelFile(
    '("/afs/ece.cmu.edu/class/ece320/F10/gpdk090_v4.5/libs.oa22/gpdk090/../../models/spectre/gpdk090.scs" "NN")
)
desVar(	  "C_delay" 0.58	)
run()
delay_a_b = delay(VT("/a") 0.6 1 "either" VT("/b") 0.6 1 "either" 0 0 nil nil)
plot( delay_a_b ?expr '( "delay_a_b" ) )
delay_a_c = delay(VT("/a") 0.6 1 "either" VT("/c") 0.6 1 "either" 0 0 nil nil)
plot( delay_a_c ?expr '( "delay_a_c" ) )
Rise = delay(VT("/a") 0.12 1 "rising" VT("/a") 1.08 1 "rising" 0 0 nil nil)
plot( Rise ?expr '( "Rise" ) )
Fall = delay(VT("/a") 1.08 1 "falling" VT("/a") 0.12 1 "falling" 0 0 nil nil)
plot( Fall ?expr '( "Fall" ) )
diff = (delay(VT("/a") 0.12 1 "rising" VT("/a") 1.08 1 "rising" 0 0 nil nil) - delay(VT("/a") 1.08 1 "falling" VT("/a") 0.12 1 "falling" 0 0 nil nil))
plot( diff ?expr '( "diff" ) )
modelFile(
    '("/afs/ece.cmu.edu/class/ece320/F10/gpdk090_v4.5/libs.oa22/gpdk090/../../models/spectre/gpdk090.scs" "NN")
)
desVar(	  "C_delay" 0.59	)
run()
delay_a_b = delay(VT("/a") 0.6 1 "either" VT("/b") 0.6 1 "either" 0 0 nil nil)
plot( delay_a_b ?expr '( "delay_a_b" ) )
delay_a_c = delay(VT("/a") 0.6 1 "either" VT("/c") 0.6 1 "either" 0 0 nil nil)
plot( delay_a_c ?expr '( "delay_a_c" ) )
Rise = delay(VT("/a") 0.12 1 "rising" VT("/a") 1.08 1 "rising" 0 0 nil nil)
plot( Rise ?expr '( "Rise" ) )
Fall = delay(VT("/a") 1.08 1 "falling" VT("/a") 0.12 1 "falling" 0 0 nil nil)
plot( Fall ?expr '( "Fall" ) )
diff = (delay(VT("/a") 0.12 1 "rising" VT("/a") 1.08 1 "rising" 0 0 nil nil) - delay(VT("/a") 1.08 1 "falling" VT("/a") 0.12 1 "falling" 0 0 nil nil))
plot( diff ?expr '( "diff" ) )
modelFile(
    '("/afs/ece.cmu.edu/class/ece320/F10/gpdk090_v4.5/libs.oa22/gpdk090/../../models/spectre/gpdk090.scs" "NN")
)
desVar(	  "C_delay" 0.6	)
run()
delay_a_b = delay(VT("/a") 0.6 1 "either" VT("/b") 0.6 1 "either" 0 0 nil nil)
plot( delay_a_b ?expr '( "delay_a_b" ) )
delay_a_c = delay(VT("/a") 0.6 1 "either" VT("/c") 0.6 1 "either" 0 0 nil nil)
plot( delay_a_c ?expr '( "delay_a_c" ) )
Rise = delay(VT("/a") 0.12 1 "rising" VT("/a") 1.08 1 "rising" 0 0 nil nil)
plot( Rise ?expr '( "Rise" ) )
Fall = delay(VT("/a") 1.08 1 "falling" VT("/a") 0.12 1 "falling" 0 0 nil nil)
plot( Fall ?expr '( "Fall" ) )
diff = (delay(VT("/a") 0.12 1 "rising" VT("/a") 1.08 1 "rising" 0 0 nil nil) - delay(VT("/a") 1.08 1 "falling" VT("/a") 0.12 1 "falling" 0 0 nil nil))
plot( diff ?expr '( "diff" ) )
modelFile(
    '("/afs/ece.cmu.edu/class/ece320/F10/gpdk090_v4.5/libs.oa22/gpdk090/../../models/spectre/gpdk090.scs" "NN")
)
desVar(	  "C_delay" 0.62	)
run()
delay_a_b = delay(VT("/a") 0.6 1 "either" VT("/b") 0.6 1 "either" 0 0 nil nil)
plot( delay_a_b ?expr '( "delay_a_b" ) )
delay_a_c = delay(VT("/a") 0.6 1 "either" VT("/c") 0.6 1 "either" 0 0 nil nil)
plot( delay_a_c ?expr '( "delay_a_c" ) )
Rise = delay(VT("/a") 0.12 1 "rising" VT("/a") 1.08 1 "rising" 0 0 nil nil)
plot( Rise ?expr '( "Rise" ) )
Fall = delay(VT("/a") 1.08 1 "falling" VT("/a") 0.12 1 "falling" 0 0 nil nil)
plot( Fall ?expr '( "Fall" ) )
diff = (delay(VT("/a") 0.12 1 "rising" VT("/a") 1.08 1 "rising" 0 0 nil nil) - delay(VT("/a") 1.08 1 "falling" VT("/a") 0.12 1 "falling" 0 0 nil nil))
plot( diff ?expr '( "diff" ) )
modelFile(
    '("/afs/ece.cmu.edu/class/ece320/F10/gpdk090_v4.5/libs.oa22/gpdk090/../../models/spectre/gpdk090.scs" "NN")
)
desVar(	  "C_delay" 0.61	)
run()
delay_a_b = delay(VT("/a") 0.6 1 "either" VT("/b") 0.6 1 "either" 0 0 nil nil)
plot( delay_a_b ?expr '( "delay_a_b" ) )
delay_a_c = delay(VT("/a") 0.6 1 "either" VT("/c") 0.6 1 "either" 0 0 nil nil)
plot( delay_a_c ?expr '( "delay_a_c" ) )
Rise = delay(VT("/a") 0.12 1 "rising" VT("/a") 1.08 1 "rising" 0 0 nil nil)
plot( Rise ?expr '( "Rise" ) )
Fall = delay(VT("/a") 1.08 1 "falling" VT("/a") 0.12 1 "falling" 0 0 nil nil)
plot( Fall ?expr '( "Fall" ) )
diff = (delay(VT("/a") 0.12 1 "rising" VT("/a") 1.08 1 "rising" 0 0 nil nil) - delay(VT("/a") 1.08 1 "falling" VT("/a") 0.12 1 "falling" 0 0 nil nil))
plot( diff ?expr '( "diff" ) )
modelFile(
    '("/afs/ece.cmu.edu/class/ece320/F10/gpdk090_v4.5/libs.oa22/gpdk090/../../models/spectre/gpdk090.scs" "NN")
)
desVar(	  "C_delay" 0.615	)
run()
delay_a_b = delay(VT("/a") 0.6 1 "either" VT("/b") 0.6 1 "either" 0 0 nil nil)
plot( delay_a_b ?expr '( "delay_a_b" ) )
delay_a_c = delay(VT("/a") 0.6 1 "either" VT("/c") 0.6 1 "either" 0 0 nil nil)
plot( delay_a_c ?expr '( "delay_a_c" ) )
Rise = delay(VT("/a") 0.12 1 "rising" VT("/a") 1.08 1 "rising" 0 0 nil nil)
plot( Rise ?expr '( "Rise" ) )
Fall = delay(VT("/a") 1.08 1 "falling" VT("/a") 0.12 1 "falling" 0 0 nil nil)
plot( Fall ?expr '( "Fall" ) )
diff = (delay(VT("/a") 0.12 1 "rising" VT("/a") 1.08 1 "rising" 0 0 nil nil) - delay(VT("/a") 1.08 1 "falling" VT("/a") 0.12 1 "falling" 0 0 nil nil))
plot( diff ?expr '( "diff" ) )
modelFile(
    '("/afs/ece.cmu.edu/class/ece320/F10/gpdk090_v4.5/libs.oa22/gpdk090/../../models/spectre/gpdk090.scs" "NN")
)
desVar(	  "C_delay" 0.611	)
run()
delay_a_b = delay(VT("/a") 0.6 1 "either" VT("/b") 0.6 1 "either" 0 0 nil nil)
plot( delay_a_b ?expr '( "delay_a_b" ) )
delay_a_c = delay(VT("/a") 0.6 1 "either" VT("/c") 0.6 1 "either" 0 0 nil nil)
plot( delay_a_c ?expr '( "delay_a_c" ) )
Rise = delay(VT("/a") 0.12 1 "rising" VT("/a") 1.08 1 "rising" 0 0 nil nil)
plot( Rise ?expr '( "Rise" ) )
Fall = delay(VT("/a") 1.08 1 "falling" VT("/a") 0.12 1 "falling" 0 0 nil nil)
plot( Fall ?expr '( "Fall" ) )
diff = (delay(VT("/a") 0.12 1 "rising" VT("/a") 1.08 1 "rising" 0 0 nil nil) - delay(VT("/a") 1.08 1 "falling" VT("/a") 0.12 1 "falling" 0 0 nil nil))
plot( diff ?expr '( "diff" ) )
modelFile(
    '("/afs/ece.cmu.edu/class/ece320/F10/gpdk090_v4.5/libs.oa22/gpdk090/../../models/spectre/gpdk090.scs" "NN")
)
desVar(	  "C_delay" 0.609	)
run()
delay_a_b = delay(VT("/a") 0.6 1 "either" VT("/b") 0.6 1 "either" 0 0 nil nil)
plot( delay_a_b ?expr '( "delay_a_b" ) )
delay_a_c = delay(VT("/a") 0.6 1 "either" VT("/c") 0.6 1 "either" 0 0 nil nil)
plot( delay_a_c ?expr '( "delay_a_c" ) )
Rise = delay(VT("/a") 0.12 1 "rising" VT("/a") 1.08 1 "rising" 0 0 nil nil)
plot( Rise ?expr '( "Rise" ) )
Fall = delay(VT("/a") 1.08 1 "falling" VT("/a") 0.12 1 "falling" 0 0 nil nil)
plot( Fall ?expr '( "Fall" ) )
diff = (delay(VT("/a") 0.12 1 "rising" VT("/a") 1.08 1 "rising" 0 0 nil nil) - delay(VT("/a") 1.08 1 "falling" VT("/a") 0.12 1 "falling" 0 0 nil nil))
plot( diff ?expr '( "diff" ) )
modelFile(
    '("/afs/ece.cmu.edu/class/ece320/F10/gpdk090_v4.5/libs.oa22/gpdk090/../../models/spectre/gpdk090.scs" "NN")
)
desVar(	  "C_delay" 605m	)
run()
delay_a_b = delay(VT("/a") 0.6 1 "either" VT("/b") 0.6 1 "either" 0 0 nil nil)
plot( delay_a_b ?expr '( "delay_a_b" ) )
delay_a_c = delay(VT("/a") 0.6 1 "either" VT("/c") 0.6 1 "either" 0 0 nil nil)
plot( delay_a_c ?expr '( "delay_a_c" ) )
Rise = delay(VT("/a") 0.12 1 "rising" VT("/a") 1.08 1 "rising" 0 0 nil nil)
plot( Rise ?expr '( "Rise" ) )
Fall = delay(VT("/a") 1.08 1 "falling" VT("/a") 0.12 1 "falling" 0 0 nil nil)
plot( Fall ?expr '( "Fall" ) )
diff = (delay(VT("/a") 0.12 1 "rising" VT("/a") 1.08 1 "rising" 0 0 nil nil) - delay(VT("/a") 1.08 1 "falling" VT("/a") 0.12 1 "falling" 0 0 nil nil))
plot( diff ?expr '( "diff" ) )
modelFile(
    '("/afs/ece.cmu.edu/class/ece320/F10/gpdk090_v4.5/libs.oa22/gpdk090/../../models/spectre/gpdk090.scs" "NN")
)
desVar(	  "C_delay" 607m	)
run()
delay_a_b = delay(VT("/a") 0.6 1 "either" VT("/b") 0.6 1 "either" 0 0 nil nil)
plot( delay_a_b ?expr '( "delay_a_b" ) )
delay_a_c = delay(VT("/a") 0.6 1 "either" VT("/c") 0.6 1 "either" 0 0 nil nil)
plot( delay_a_c ?expr '( "delay_a_c" ) )
Rise = delay(VT("/a") 0.12 1 "rising" VT("/a") 1.08 1 "rising" 0 0 nil nil)
plot( Rise ?expr '( "Rise" ) )
Fall = delay(VT("/a") 1.08 1 "falling" VT("/a") 0.12 1 "falling" 0 0 nil nil)
plot( Fall ?expr '( "Fall" ) )
diff = (delay(VT("/a") 0.12 1 "rising" VT("/a") 1.08 1 "rising" 0 0 nil nil) - delay(VT("/a") 1.08 1 "falling" VT("/a") 0.12 1 "falling" 0 0 nil nil))
plot( diff ?expr '( "diff" ) )

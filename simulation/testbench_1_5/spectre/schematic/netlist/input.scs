// Design: lab9/testbench_1_5
simulator lang=spectre
global 0
parameters beta=2.2 C_delay=4.449 lambda=50n
include "/afs/ece.cmu.edu/class/ece320/F10/gpdk090_v4.5/libs.oa22/gpdk090/../../models/spectre/gpdk090.scs" section=NN

// lab9/inverter/schematic
subckt inverter GND IN OUT VDD
parameters width length
    NM0 (OUT IN GND GND) gpdk090_nmos1v w=(width) l=length m=(1)*(1) simM=(1)*(1)
    PM0 (OUT IN VDD VDD) gpdk090_pmos1v w=(width*beta) l=length m=(1)*(1) simM=(1)*(1)
ends inverter

// lab9/testbench_1_5/schematic
I3 (0 a b VDD) inverter width=8*8*lambda length=2*lambda
I2 (0 a c VDD) inverter width=8*8*lambda length=2*lambda
I1 (0 net12 a VDD) inverter width=4*8*lambda length=2*lambda
I0 (0 IN net12 VDD) inverter width=8*lambda length=2*lambda
NM0 (c 0 0 0) gpdk090_nmos1v w=(120n) l=100n m=(1)*(1) simM=(1)*(1)
C0 (b 0) gpdk090_mimcap area=(4u)*(4u) perim=2*(4u)+2*(4u) m=1*C_delay
V2 (VDD 0) vsource dc=1.2 type=dc
V0 (IN 0) vsource type=pulse val0=0 val1=1.2 period=1n delay=50p rise=50p fall=50p width=300p
simulatorOptions options temp=27
tran tran stop=5n

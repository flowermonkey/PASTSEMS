simulator( 'spectre )
design(	 "/afs/ece.cmu.edu/usr/bflores/simulation/testbench_1_6/spectre/schematic/netlist/netlist")
resultsDir( "/afs/ece.cmu.edu/usr/bflores/simulation/testbench_1_6/spectre/schematic" )
modelFile(
    '("/afs/ece.cmu.edu/class/ece320/F10/gpdk090_v4.5/libs.oa22/gpdk090/../../models/spectre/gpdk090.scs" "NN")
)
analysis('tran ?stop "5n"  )
desVar(	  "lambda" 50n	)
desVar(	  "beta" 2.249	)
temp( 27 )
run()
Rise = delay(VT("/a") 0.12 1 "rising" VT("/a") 1.08 1 "rising" 0 0 nil nil)
plot( Rise ?expr '( "Rise" ) )
Fall = delay(VT("/a") 1.08 1 "falling" VT("/a") 0.12 1 "falling" 0 0 nil nil)
plot( Fall ?expr '( "Fall" ) )
modelFile(
    '("/afs/ece.cmu.edu/class/ece320/F10/gpdk090_v4.5/libs.oa22/gpdk090/../../models/spectre/gpdk090.scs" "NN")
)
desVar(	  "beta" 2.23	)
run()
Rise = delay(VT("/a") 0.12 1 "rising" VT("/a") 1.08 1 "rising" 0 0 nil nil)
plot( Rise ?expr '( "Rise" ) )
Fall = delay(VT("/a") 1.08 1 "falling" VT("/a") 0.12 1 "falling" 0 0 nil nil)
plot( Fall ?expr '( "Fall" ) )
modelFile(
    '("/afs/ece.cmu.edu/class/ece320/F10/gpdk090_v4.5/libs.oa22/gpdk090/../../models/spectre/gpdk090.scs" "NN")
)
desVar(	  "beta" 2.22	)
run()
Rise = delay(VT("/a") 0.12 1 "rising" VT("/a") 1.08 1 "rising" 0 0 nil nil)
plot( Rise ?expr '( "Rise" ) )
Fall = delay(VT("/a") 1.08 1 "falling" VT("/a") 0.12 1 "falling" 0 0 nil nil)
plot( Fall ?expr '( "Fall" ) )
modelFile(
    '("/afs/ece.cmu.edu/class/ece320/F10/gpdk090_v4.5/libs.oa22/gpdk090/../../models/spectre/gpdk090.scs" "NN")
)
desVar(	  "beta" 2.229	)
run()
Rise = delay(VT("/a") 0.12 1 "rising" VT("/a") 1.08 1 "rising" 0 0 nil nil)
plot( Rise ?expr '( "Rise" ) )
Fall = delay(VT("/a") 1.08 1 "falling" VT("/a") 0.12 1 "falling" 0 0 nil nil)
plot( Fall ?expr '( "Fall" ) )
modelFile(
    '("/afs/ece.cmu.edu/class/ece320/F10/gpdk090_v4.5/libs.oa22/gpdk090/../../models/spectre/gpdk090.scs" "NN")
)
desVar(	  "beta" 2.225	)
run()
Rise = delay(VT("/a") 0.12 1 "rising" VT("/a") 1.08 1 "rising" 0 0 nil nil)
plot( Rise ?expr '( "Rise" ) )
Fall = delay(VT("/a") 1.08 1 "falling" VT("/a") 0.12 1 "falling" 0 0 nil nil)
plot( Fall ?expr '( "Fall" ) )
modelFile(
    '("/afs/ece.cmu.edu/class/ece320/F10/gpdk090_v4.5/libs.oa22/gpdk090/../../models/spectre/gpdk090.scs" "NN")
)
desVar(	  "beta" 2.227	)
run()
Rise = delay(VT("/a") 0.12 1 "rising" VT("/a") 1.08 1 "rising" 0 0 nil nil)
plot( Rise ?expr '( "Rise" ) )
Fall = delay(VT("/a") 1.08 1 "falling" VT("/a") 0.12 1 "falling" 0 0 nil nil)
plot( Fall ?expr '( "Fall" ) )
modelFile(
    '("/afs/ece.cmu.edu/class/ece320/F10/gpdk090_v4.5/libs.oa22/gpdk090/../../models/spectre/gpdk090.scs" "NN")
)
desVar(	  "beta" 2.219	)
run()
Rise = delay(VT("/a") 0.12 1 "rising" VT("/a") 1.08 1 "rising" 0 0 nil nil)
plot( Rise ?expr '( "Rise" ) )
Fall = delay(VT("/a") 1.08 1 "falling" VT("/a") 0.12 1 "falling" 0 0 nil nil)
plot( Fall ?expr '( "Fall" ) )
modelFile(
    '("/afs/ece.cmu.edu/class/ece320/F10/gpdk090_v4.5/libs.oa22/gpdk090/../../models/spectre/gpdk090.scs" "NN")
)
desVar(	  "beta" 2.22	)
run()
Rise = delay(VT("/a") 0.12 1 "rising" VT("/a") 1.08 1 "rising" 0 0 nil nil)
plot( Rise ?expr '( "Rise" ) )
Fall = delay(VT("/a") 1.08 1 "falling" VT("/a") 0.12 1 "falling" 0 0 nil nil)
plot( Fall ?expr '( "Fall" ) )
modelFile(
    '("/afs/ece.cmu.edu/class/ece320/F10/gpdk090_v4.5/libs.oa22/gpdk090/../../models/spectre/gpdk090.scs" "NN")
)
desVar(	  "beta" 2.222	)
run()
Rise = delay(VT("/a") 0.12 1 "rising" VT("/a") 1.08 1 "rising" 0 0 nil nil)
plot( Rise ?expr '( "Rise" ) )
Fall = delay(VT("/a") 1.08 1 "falling" VT("/a") 0.12 1 "falling" 0 0 nil nil)
plot( Fall ?expr '( "Fall" ) )
modelFile(
    '("/afs/ece.cmu.edu/class/ece320/F10/gpdk090_v4.5/libs.oa22/gpdk090/../../models/spectre/gpdk090.scs" "NN")
)
desVar(	  "beta" 2.23	)
run()
Rise = delay(VT("/a") 0.12 1 "rising" VT("/a") 1.08 1 "rising" 0 0 nil nil)
plot( Rise ?expr '( "Rise" ) )
Fall = delay(VT("/a") 1.08 1 "falling" VT("/a") 0.12 1 "falling" 0 0 nil nil)
plot( Fall ?expr '( "Fall" ) )
modelFile(
    '("/afs/ece.cmu.edu/class/ece320/F10/gpdk090_v4.5/libs.oa22/gpdk090/../../models/spectre/gpdk090.scs" "NN")
)
desVar(	  "beta" 2.231	)
run()
Rise = delay(VT("/a") 0.12 1 "rising" VT("/a") 1.08 1 "rising" 0 0 nil nil)
plot( Rise ?expr '( "Rise" ) )
Fall = delay(VT("/a") 1.08 1 "falling" VT("/a") 0.12 1 "falling" 0 0 nil nil)
plot( Fall ?expr '( "Fall" ) )
modelFile(
    '("/afs/ece.cmu.edu/class/ece320/F10/gpdk090_v4.5/libs.oa22/gpdk090/../../models/spectre/gpdk090.scs" "NN")
)
desVar(	  "beta" 2.232	)
run()
Rise = delay(VT("/a") 0.12 1 "rising" VT("/a") 1.08 1 "rising" 0 0 nil nil)
plot( Rise ?expr '( "Rise" ) )
Fall = delay(VT("/a") 1.08 1 "falling" VT("/a") 0.12 1 "falling" 0 0 nil nil)
plot( Fall ?expr '( "Fall" ) )
modelFile(
    '("/afs/ece.cmu.edu/class/ece320/F10/gpdk090_v4.5/libs.oa22/gpdk090/../../models/spectre/gpdk090.scs" "NN")
)
desVar(	  "beta" 2.235	)
run()
Rise = delay(VT("/a") 0.12 1 "rising" VT("/a") 1.08 1 "rising" 0 0 nil nil)
plot( Rise ?expr '( "Rise" ) )
Fall = delay(VT("/a") 1.08 1 "falling" VT("/a") 0.12 1 "falling" 0 0 nil nil)
plot( Fall ?expr '( "Fall" ) )
modelFile(
    '("/afs/ece.cmu.edu/class/ece320/F10/gpdk090_v4.5/libs.oa22/gpdk090/../../models/spectre/gpdk090.scs" "NN")
)
desVar(	  "beta" 2.24	)
run()
Rise = delay(VT("/a") 0.12 1 "rising" VT("/a") 1.08 1 "rising" 0 0 nil nil)
plot( Rise ?expr '( "Rise" ) )
Fall = delay(VT("/a") 1.08 1 "falling" VT("/a") 0.12 1 "falling" 0 0 nil nil)
plot( Fall ?expr '( "Fall" ) )
modelFile(
    '("/afs/ece.cmu.edu/class/ece320/F10/gpdk090_v4.5/libs.oa22/gpdk090/../../models/spectre/gpdk090.scs" "NN")
)
desVar(	  "beta" 2.25	)
run()
Rise = delay(VT("/a") 0.12 1 "rising" VT("/a") 1.08 1 "rising" 0 0 nil nil)
plot( Rise ?expr '( "Rise" ) )
Fall = delay(VT("/a") 1.08 1 "falling" VT("/a") 0.12 1 "falling" 0 0 nil nil)
plot( Fall ?expr '( "Fall" ) )
modelFile(
    '("/afs/ece.cmu.edu/class/ece320/F10/gpdk090_v4.5/libs.oa22/gpdk090/../../models/spectre/gpdk090.scs" "NN")
)
desVar(	  "beta" 2.3	)
run()
Rise = delay(VT("/a") 0.12 1 "rising" VT("/a") 1.08 1 "rising" 0 0 nil nil)
plot( Rise ?expr '( "Rise" ) )
Fall = delay(VT("/a") 1.08 1 "falling" VT("/a") 0.12 1 "falling" 0 0 nil nil)
plot( Fall ?expr '( "Fall" ) )
modelFile(
    '("/afs/ece.cmu.edu/class/ece320/F10/gpdk090_v4.5/libs.oa22/gpdk090/../../models/spectre/gpdk090.scs" "NN")
)
desVar(	  "beta" 2.28	)
run()
Rise = delay(VT("/a") 0.12 1 "rising" VT("/a") 1.08 1 "rising" 0 0 nil nil)
plot( Rise ?expr '( "Rise" ) )
Fall = delay(VT("/a") 1.08 1 "falling" VT("/a") 0.12 1 "falling" 0 0 nil nil)
plot( Fall ?expr '( "Fall" ) )
modelFile(
    '("/afs/ece.cmu.edu/class/ece320/F10/gpdk090_v4.5/libs.oa22/gpdk090/../../models/spectre/gpdk090.scs" "NN")
)
desVar(	  "beta" 2.27	)
run()
Rise = delay(VT("/a") 0.12 1 "rising" VT("/a") 1.08 1 "rising" 0 0 nil nil)
plot( Rise ?expr '( "Rise" ) )
Fall = delay(VT("/a") 1.08 1 "falling" VT("/a") 0.12 1 "falling" 0 0 nil nil)
plot( Fall ?expr '( "Fall" ) )
modelFile(
    '("/afs/ece.cmu.edu/class/ece320/F10/gpdk090_v4.5/libs.oa22/gpdk090/../../models/spectre/gpdk090.scs" "NN")
)
desVar(	  "beta" 2.26	)
run()
Rise = delay(VT("/a") 0.12 1 "rising" VT("/a") 1.08 1 "rising" 0 0 nil nil)
plot( Rise ?expr '( "Rise" ) )
Fall = delay(VT("/a") 1.08 1 "falling" VT("/a") 0.12 1 "falling" 0 0 nil nil)
plot( Fall ?expr '( "Fall" ) )
modelFile(
    '("/afs/ece.cmu.edu/class/ece320/F10/gpdk090_v4.5/libs.oa22/gpdk090/../../models/spectre/gpdk090.scs" "NN")
)
desVar(	  "beta" 2.261	)
run()
Rise = delay(VT("/a") 0.12 1 "rising" VT("/a") 1.08 1 "rising" 0 0 nil nil)
plot( Rise ?expr '( "Rise" ) )
Fall = delay(VT("/a") 1.08 1 "falling" VT("/a") 0.12 1 "falling" 0 0 nil nil)
plot( Fall ?expr '( "Fall" ) )
modelFile(
    '("/afs/ece.cmu.edu/class/ece320/F10/gpdk090_v4.5/libs.oa22/gpdk090/../../models/spectre/gpdk090.scs" "NN")
)
desVar(	  "beta" 2.262	)
run()
Rise = delay(VT("/a") 0.12 1 "rising" VT("/a") 1.08 1 "rising" 0 0 nil nil)
plot( Rise ?expr '( "Rise" ) )
Fall = delay(VT("/a") 1.08 1 "falling" VT("/a") 0.12 1 "falling" 0 0 nil nil)
plot( Fall ?expr '( "Fall" ) )
modelFile(
    '("/afs/ece.cmu.edu/class/ece320/F10/gpdk090_v4.5/libs.oa22/gpdk090/../../models/spectre/gpdk090.scs" "NN")
)
desVar(	  "beta" 2.263	)
run()
Rise = delay(VT("/a") 0.12 1 "rising" VT("/a") 1.08 1 "rising" 0 0 nil nil)
plot( Rise ?expr '( "Rise" ) )
Fall = delay(VT("/a") 1.08 1 "falling" VT("/a") 0.12 1 "falling" 0 0 nil nil)
plot( Fall ?expr '( "Fall" ) )
modelFile(
    '("/afs/ece.cmu.edu/class/ece320/F10/gpdk090_v4.5/libs.oa22/gpdk090/../../models/spectre/gpdk090.scs" "NN")
)
desVar(	  "beta" 2.64	)
run()
Rise = delay(VT("/a") 0.12 1 "rising" VT("/a") 1.08 1 "rising" 0 0 nil nil)
plot( Rise ?expr '( "Rise" ) )
Fall = delay(VT("/a") 1.08 1 "falling" VT("/a") 0.12 1 "falling" 0 0 nil nil)
plot( Fall ?expr '( "Fall" ) )
modelFile(
    '("/afs/ece.cmu.edu/class/ece320/F10/gpdk090_v4.5/libs.oa22/gpdk090/../../models/spectre/gpdk090.scs" "NN")
)
desVar(	  "beta" 2.6	)
run()
Rise = delay(VT("/a") 0.12 1 "rising" VT("/a") 1.08 1 "rising" 0 0 nil nil)
plot( Rise ?expr '( "Rise" ) )
Fall = delay(VT("/a") 1.08 1 "falling" VT("/a") 0.12 1 "falling" 0 0 nil nil)
plot( Fall ?expr '( "Fall" ) )
modelFile(
    '("/afs/ece.cmu.edu/class/ece320/F10/gpdk090_v4.5/libs.oa22/gpdk090/../../models/spectre/gpdk090.scs" "NN")
)
desVar(	  "beta" 2.61	)
run()
Rise = delay(VT("/a") 0.12 1 "rising" VT("/a") 1.08 1 "rising" 0 0 nil nil)
plot( Rise ?expr '( "Rise" ) )
Fall = delay(VT("/a") 1.08 1 "falling" VT("/a") 0.12 1 "falling" 0 0 nil nil)
plot( Fall ?expr '( "Fall" ) )
modelFile(
    '("/afs/ece.cmu.edu/class/ece320/F10/gpdk090_v4.5/libs.oa22/gpdk090/../../models/spectre/gpdk090.scs" "NN")
)
desVar(	  "beta" 2.62	)
run()
Rise = delay(VT("/a") 0.12 1 "rising" VT("/a") 1.08 1 "rising" 0 0 nil nil)
plot( Rise ?expr '( "Rise" ) )
Fall = delay(VT("/a") 1.08 1 "falling" VT("/a") 0.12 1 "falling" 0 0 nil nil)
plot( Fall ?expr '( "Fall" ) )

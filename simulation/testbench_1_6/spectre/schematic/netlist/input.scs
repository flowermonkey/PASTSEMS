// Design: lab9/testbench_1_6
simulator lang=spectre
global 0
parameters beta=2.249 lambda=50n
include "/afs/ece.cmu.edu/class/ece320/F10/gpdk090_v4.5/libs.oa22/gpdk090/../../models/spectre/gpdk090.scs" section=NN

// lab9/inverter/schematic
subckt inverter GND IN OUT VDD
parameters width length
    NM0 (OUT IN GND GND) gpdk090_nmos1v w=(width) l=length m=(1)*(1) simM=(1)*(1)
    PM0 (OUT IN VDD VDD) gpdk090_pmos1v w=(width*beta) l=length m=(1)*(1) simM=(1)*(1)
ends inverter

// lab9/testbench_1_6/schematic
I0 (0 IN a VDD) inverter width=8*lambda length=2*lambda
I1 (0 a OUT VDD) inverter width=4*2*lambda length=2*lambda
V2 (VDD 0) vsource dc=1.2 type=dc
V0 (IN 0) vsource type=pulse val0=0 val1=1.2 period=1n delay=50p rise=50p fall=50p width=300p
simulatorOptions options temp=27
tran tran stop=5n

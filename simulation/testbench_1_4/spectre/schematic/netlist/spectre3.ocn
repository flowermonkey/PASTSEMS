simulator( 'spectre )
design(	 "/afs/ece.cmu.edu/usr/bflores/simulation/testbench_1_4/spectre/schematic/netlist/netlist")
resultsDir( "/afs/ece.cmu.edu/usr/bflores/simulation/testbench_1_4/spectre/schematic" )
modelFile(
    '("/afs/ece.cmu.edu/class/ece320/F10/gpdk090_v4.5/libs.oa22/gpdk090/../../models/spectre/gpdk090.scs" "NN")
)
analysis('tran ?stop "5n"  )
desVar(	  "lambda" 50n	)
desVar(	  "beta" 2.249	)
temp( 27 )
run()
rise\ delay = delay(VT("/IN") 0.12 1 "rising" VT("/OUT") 1.08 1 "rising" 0 0 nil nil)
plot( rise\ delay ?expr '( "rise delay" ) )
fall\ delay = delay(VT("/IN") 0.12 1 "falling" VT("/OUT") 1.08 1 "falling" 0 0 nil nil)
plot( fall\ delay ?expr '( "fall delay" ) )
modelFile(
    '("/afs/ece.cmu.edu/class/ece320/F10/gpdk090_v4.5/libs.oa22/gpdk090/../../models/spectre/gpdk090.scs" "NN")
)
run()
rise\ delay = delay(VT("/IN") 0.6 1 "either" VT("/OUT") 0.6 1 "either) ")
plot( rise\ delay ?expr '( "rise delay" ) )
fall\ delay = delay(VT("/IN") 0.12 1 "falling" VT("/OUT") 1.08 1 "falling" 0 0 nil nil)
plot( fall\ delay ?expr '( "fall delay" ) )
modelFile(
    '("/afs/ece.cmu.edu/class/ece320/F10/gpdk090_v4.5/libs.oa22/gpdk090/../../models/spectre/gpdk090.scs" "NN")
)
run()
rise\ delay = delay(VT("/IN") 0.6 1 "rising" VT("/OUT") 0.6 1 "falling" 0 0 nil nil)
plot( rise\ delay ?expr '( "rise delay" ) )
fall\ delay = delay(VT("/IN") 0.6 1 "falling" VT("/OUT") 0.6 1 "rising" 0 0 nil nil)
plot( fall\ delay ?expr '( "fall delay" ) )
modelFile(
    '("/afs/ece.cmu.edu/class/ece320/F10/gpdk090_v4.5/libs.oa22/gpdk090/../../models/spectre/gpdk090.scs" "NN")
)
run()
rise\ delay = delay(VT("/IN") 0.6 1 "rising" VT("/OUT") 0.6 1 "falling" 0 0 nil nil)
plot( rise\ delay ?expr '( "rise delay" ) )
fall\ delay = delay(VT("/OUT") 0.6 1 "falling" VT("/IN") 0.6 1 "rising" 0 0 nil nil)
plot( fall\ delay ?expr '( "fall delay" ) )

simulator( 'spectre )
design(	 "/afs/ece.cmu.edu/usr/bflores/simulation/testbench_1_4/spectre/schematic/netlist/netlist")
resultsDir( "/afs/ece.cmu.edu/usr/bflores/simulation/testbench_1_4/spectre/schematic" )
modelFile(
    '("/afs/ece.cmu.edu/class/ece320/F10/gpdk090_v4.5/libs.oa22/gpdk090/../../models/spectre/gpdk090.scs" "NN")
)
analysis('tran ?stop "5n"  )
desVar(	  "lambda" 50n	)
desVar(	  "beta" 2.249	)
save( 'i "/I0/IN" )
temp( 27 )
run()
selectResult( 'tran )
plot(getData("/I0/IN") getData("/VDD") )
C_eff_power = (integ(IT("/I0/IN") 0 1e-10) / 1.2)
plot( C_eff_power ?expr '( "C_eff_power" ) )

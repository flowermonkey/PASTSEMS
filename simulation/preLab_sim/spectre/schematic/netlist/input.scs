// Design: lab9/preLab_sim
simulator lang=spectre
global 0
parameters beta=2 lambda=50n
include "/afs/ece.cmu.edu/class/ece320/F10/gpdk090_v4.5/libs.oa22/gpdk090/../../models/spectre/gpdk090.scs" section=NN

// lab9/inverter/schematic
subckt inverter GND IN OUT VDD
parameters width length
    NM0 (OUT IN GND GND) gpdk090_nmos1v w=(width) l=length m=(1)*(1) simM=(1)*(1)
    PM0 (OUT IN VDD VDD) gpdk090_pmos1v w=(width*beta) l=length m=(1)*(1) simM=(1)*(1)
ends inverter

// lab9/preLab_sim/schematic
I0 (GND IN OUT VDD) inverter width=8*lambda length=2*lambda
include "./_graphical_stimuli.scs"
simulatorOptions options temp=27
tran tran stop=1n

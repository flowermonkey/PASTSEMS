simulator( 'spectre )
design(	 "/afs/ece.cmu.edu/usr/bflores/simulation/preLab_sim/spectre/schematic/netlist/netlist")
resultsDir( "/afs/ece.cmu.edu/usr/bflores/simulation/preLab_sim/spectre/schematic" )
modelFile(
    '("/afs/ece.cmu.edu/class/ece320/F10/gpdk090_v4.5/libs.oa22/gpdk090/../../models/spectre/gpdk090.scs" "NN")
)
analysis('tran ?stop "1n"  )
desVar(	  "lambda" 50n	)
desVar(	  "beta" 2	)
temp( 27 )
run()
selectResult( 'tran )
plot(getData("/OUT") getData("/IN") )
Pro\ Delay = cross(VT("/OUT") 1.2 1 "either" nil nil)
plot( Pro\ Delay ?expr '( "Pro Delay" ) )
modelFile(
    '("/afs/ece.cmu.edu/class/ece320/F10/gpdk090_v4.5/libs.oa22/gpdk090/../../models/spectre/gpdk090.scs" "NN")
)
run()
selectResult( 'tran )
plot(getData("/OUT") getData("/IN") )
Pro\ Delay = cross(VT("/OUT") 1.2 1 "either" nil nil)
plot( Pro\ Delay ?expr '( "Pro Delay" ) )
modelFile(
    '("/afs/ece.cmu.edu/class/ece320/F10/gpdk090_v4.5/libs.oa22/gpdk090/../../models/spectre/gpdk090.scs" "NN")
)
run()
selectResult( 'tran )
plot(getData("/OUT") getData("/IN") )
Pro\ Delay = cross(VT("/OUT") 1.2 1 "either" nil nil)
plot( Pro\ Delay ?expr '( "Pro Delay" ) )
modelFile(
    '("/afs/ece.cmu.edu/class/ece320/F10/gpdk090_v4.5/libs.oa22/gpdk090/../../models/spectre/gpdk090.scs" "NN")
)
run()
selectResult( 'tran )
plot(getData("/IN") getData("/OUT") )
Pro\ Delay = cross(VT("/OUT") 1.2 1 "either" nil nil)
plot( Pro\ Delay ?expr '( "Pro Delay" ) )
modelFile(
    '("/afs/ece.cmu.edu/class/ece320/F10/gpdk090_v4.5/libs.oa22/gpdk090/../../models/spectre/gpdk090.scs" "NN")
)
run()
selectResult( 'tran )
plot(getData("/IN") getData("/OUT") )
Prop\ Delay = cross(cross(VT("/OUT") 1.2 1 "either" nil nil) 1.0 1 "either" nil nil)
plot( Prop\ Delay ?expr '( "Prop Delay" ) )
modelFile(
    '("/afs/ece.cmu.edu/class/ece320/F10/gpdk090_v4.5/libs.oa22/gpdk090/../../models/spectre/gpdk090.scs" "NN")
)
run()
selectResult( 'tran )
plot(getData("/IN") getData("/OUT") )
Prop\ Delay = cross(VT("/OUT") 1.0 1 "either" nil nil)
plot( Prop\ Delay ?expr '( "Prop Delay" ) )
modelFile(
    '("/afs/ece.cmu.edu/class/ece320/F10/gpdk090_v4.5/libs.oa22/gpdk090/../../models/spectre/gpdk090.scs" "NN")
)
run()
selectResult( 'tran )
plot(getData("/IN") getData("/OUT") )
Prop\ Delay = (cross(VT("/OUT") 1.2 1 "either" nil nil) - cross(VT("/OUT") 0 1 "either" nil nil))
plot( Prop\ Delay ?expr '( "Prop Delay" ) )

simulator( 'spectre )
design(	 "/afs/ece.cmu.edu/usr/bflores/simulation/test2/spectre/schematic/netlist/netlist")
resultsDir( "/afs/ece.cmu.edu/usr/bflores/simulation/test2/spectre/schematic" )
modelFile(
    '("/afs/ece.cmu.edu/class/ece421/gpdk090_v4.4/libs.oa22/gpdk090/../../models/spectre/gpdk090.scs" "NN")
)
analysis('tran ?stop "5n"  )
desVar(	  "beta" 2	)
save( 'v "/a" "/b" )
temp( 27 )
run()
RD = delay(VT("/a") 0.12 1 "rising" VT("/a") 1.08 1 "rising" 0 0 nil nil)
plot( RD ?expr '( "RD" ) )
FD = delay(VT("/a") 1.08 1 "falling" VT("/a") 0.12 1 "falling" 0 0 nil nil)
plot( FD ?expr '( "FD" ) )
modelFile(
    '("/afs/ece.cmu.edu/class/ece421/gpdk090_v4.4/libs.oa22/gpdk090/../../models/spectre/gpdk090.scs" "NN")
)
run()
selectResult( 'tran )
plot(getData("/a") getData("/b") )
RD = delay(VT("/a") 0.12 1 "rising" VT("/a") 1.08 1 "rising" 0 0 nil nil)
plot( RD ?expr '( "RD" ) )
FD = delay(VT("/a") 1.08 1 "falling" VT("/a") 0.12 1 "falling" 0 0 nil nil)
plot( FD ?expr '( "FD" ) )
modelFile(
    '("/afs/ece.cmu.edu/class/ece421/gpdk090_v4.4/libs.oa22/gpdk090/../../models/spectre/gpdk090.scs" "NN")
)
desVar(	  "beta" 2.5	)
run()
selectResult( 'tran )
plot(getData("/a") getData("/b") )
RD = delay(VT("/a") 0.12 1 "rising" VT("/a") 1.08 1 "rising" 0 0 nil nil)
plot( RD ?expr '( "RD" ) )
FD = delay(VT("/a") 1.08 1 "falling" VT("/a") 0.12 1 "falling" 0 0 nil nil)
plot( FD ?expr '( "FD" ) )

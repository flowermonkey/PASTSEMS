// Design: lab9/test2
simulator lang=spectre
global 0
parameters beta=2
include "/afs/ece.cmu.edu/class/ece421/gpdk090_v4.4/libs.oa22/gpdk090/../../models/spectre/gpdk090.scs" section=NN

// Lab8/inverter/schematic
subckt inverter IN OUT VDD VSS
    NM0 (OUT IN VSS VSS) gpdk090_nmos1v w=(120n) l=100n m=(1)*(1) simM=(1)*(1)
    PM0 (OUT IN VDD VDD) gpdk090_pmos1v w=(120n) l=100n m=(1)*(1) simM=(1)*(1)
ends inverter

// lab9/test2/schematic
I16 (a b VDD 0) inverter
I17 (b net12 VDD 0) inverter
I18 (net12 OUT VDD 0) inverter
I14 (IN net15 VDD 0) inverter
I15 (net15 a VDD 0) inverter
V2 (VDD 0) vsource dc=1.2 type=dc
V0 (IN 0) vsource type=pulse val0=0 val1=1.2 period=1n delay=50p rise=50p fall=50p width=300p
simulatorOptions options temp=27
tran tran stop=5n
save a b

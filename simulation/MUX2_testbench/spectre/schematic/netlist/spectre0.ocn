simulator( 'spectre )
design(	 "/afs/ece.cmu.edu/usr/bflores/simulation/MUX2_testbench/spectre/schematic/netlist/netlist")
resultsDir( "/afs/ece.cmu.edu/usr/bflores/simulation/MUX2_testbench/spectre/schematic" )
modelFile(
    '("/afs/ece.cmu.edu/class/ece320/F10/gpdk090_v4.5/libs.oa22/gpdk090/../../models/spectre/gpdk090.scs" "NN")
)
analysis('tran ?stop "5n"  )
temp( 27 )
run()
selectResult( 'tran )
plot(getData("/D0") getData("/D1") getData("/OUT1") getData("/OUT2") getData("/OUT3") getData("/OUT4") getData("/SEL0") )
Rise\ Delay = (cross(VT("/OUT1") 1.0 1 "rising" nil nil) - cross(VT("/OUT1") 0 1 "rising" nil nil))
plot( Rise\ Delay ?expr '( "Rise Delay" ) )
Falling\ Delay = (cross(VT("/OUT1") 0 1 "falling" nil nil) - cross(VT("/OUT1") 1.2 1 "falling" nil nil))
plot( Falling\ Delay ?expr '( "Falling Delay" ) )
modelFile(
    '("/afs/ece.cmu.edu/class/ece320/F10/gpdk090_v4.5/libs.oa22/gpdk090/../../models/spectre/gpdk090.scs" "NN")
)
run()
selectResult( 'tran )
plot(getData("/OUT1") )
Rise\ Delay = (cross(VT("/OUT1") 1.0 1 "rising" nil nil) - cross(VT("/OUT1") 0 1 "rising" nil nil))
plot( Rise\ Delay ?expr '( "Rise Delay" ) )
Falling\ Delay = (cross(VT("/OUT1") 0 1 "falling" nil nil) - cross(VT("/OUT1") 1.2 1 "falling" nil nil))
plot( Falling\ Delay ?expr '( "Falling Delay" ) )
modelFile(
    '("/afs/ece.cmu.edu/class/ece320/F10/gpdk090_v4.5/libs.oa22/gpdk090/../../models/spectre/gpdk090.scs" "NN")
)
run()
selectResult( 'tran )
plot(getData("/OUT1") )
Rise\ Delay = (cross(VT("/OUT1") 1.0 1 "rising" nil nil))
plot( Rise\ Delay ?expr '( "Rise Delay" ) )
Falling\ Delay = (cross(VT("/OUT1") 0 1 "falling" nil nil) - cross(VT("/OUT1") 1.2 1 "falling" nil nil))
plot( Falling\ Delay ?expr '( "Falling Delay" ) )
modelFile(
    '("/afs/ece.cmu.edu/class/ece320/F10/gpdk090_v4.5/libs.oa22/gpdk090/../../models/spectre/gpdk090.scs" "NN")
)
run()
selectResult( 'tran )
plot(getData("/OUT1") )
Rise\ Delay = cross(VT("/OUT1") 1.0 1 "rising" nil nil)
plot( Rise\ Delay ?expr '( "Rise Delay" ) )
Falling\ Delay = (cross(VT("/OUT1") 0 1 "falling" nil nil) - cross(VT("/OUT1") 1.2 1 "falling" nil nil))
plot( Falling\ Delay ?expr '( "Falling Delay" ) )
modelFile(
    '("/afs/ece.cmu.edu/class/ece320/F10/gpdk090_v4.5/libs.oa22/gpdk090/../../models/spectre/gpdk090.scs" "NN")
)
run()
selectResult( 'tran )
plot(getData("/OUT1") )
Rise\ Delay = cross(VT("/OUT1") 0 1 "rising" nil nil)
plot( Rise\ Delay ?expr '( "Rise Delay" ) )
Falling\ Delay = (cross(VT("/OUT1") 0 1 "falling" nil nil) - cross(VT("/OUT1") 1.2 1 "falling" nil nil))
plot( Falling\ Delay ?expr '( "Falling Delay" ) )
modelFile(
    '("/afs/ece.cmu.edu/class/ece320/F10/gpdk090_v4.5/libs.oa22/gpdk090/../../models/spectre/gpdk090.scs" "NN")
)
run()
selectResult( 'tran )
plot(getData("/OUT1") )
Rise\ Delay = (cross(VT("/OUT1") 1.0 1 "rising" nil nil) - cross(VT("/OUT1") 0 1 "rising" nil nil))
plot( Rise\ Delay ?expr '( "Rise Delay" ) )
Falling\ Delay = (cross(VT("/OUT1") 0 1 "falling" nil nil) - cross(VT("/OUT1") 1.2 1 "falling" nil nil))
plot( Falling\ Delay ?expr '( "Falling Delay" ) )
modelFile(
    '("/afs/ece.cmu.edu/class/ece320/F10/gpdk090_v4.5/libs.oa22/gpdk090/../../models/spectre/gpdk090.scs" "NN")
)
run()
selectResult( 'tran )
plot(getData("/OUT1") )
Rise\ Delay = (cross(VT("/OUT1") 1.0 1 "rising" nil nil) - cross(VT("/OUT1") 0 1 "rising" nil nil))
plot( Rise\ Delay ?expr '( "Rise Delay" ) )
Falling\ Delay = cross(VT("/OUT1") 0 1 "falling" nil nil)
plot( Falling\ Delay ?expr '( "Falling Delay" ) )
modelFile(
    '("/afs/ece.cmu.edu/class/ece320/F10/gpdk090_v4.5/libs.oa22/gpdk090/../../models/spectre/gpdk090.scs" "NN")
)
run()
selectResult( 'tran )
plot(getData("/OUT1") )
Rise\ Delay = (cross(VT("/OUT1") 1.0 1 "rising" nil nil) - cross(VT("/OUT1") 0 1 "rising" nil nil))
plot( Rise\ Delay ?expr '( "Rise Delay" ) )
Falling\ Delay = cross(VT("/OUT1") 0 2 "falling" nil nil)
plot( Falling\ Delay ?expr '( "Falling Delay" ) )
modelFile(
    '("/afs/ece.cmu.edu/class/ece320/F10/gpdk090_v4.5/libs.oa22/gpdk090/../../models/spectre/gpdk090.scs" "NN")
)
run()
selectResult( 'tran )
plot(getData("/OUT1") )
Rise\ Delay = (cross(VT("/OUT1") 1.0 1 "rising" nil nil) - cross(VT("/OUT1") 0 1 "rising" nil nil))
plot( Rise\ Delay ?expr '( "Rise Delay" ) )
Falling\ Delay = cross(VT("/OUT1") 0 2 "rising" nil nil)
plot( Falling\ Delay ?expr '( "Falling Delay" ) )
modelFile(
    '("/afs/ece.cmu.edu/class/ece320/F10/gpdk090_v4.5/libs.oa22/gpdk090/../../models/spectre/gpdk090.scs" "NN")
)
run()
selectResult( 'tran )
plot(getData("/OUT1") )
Rise\ Delay = (cross(VT("/OUT1") 1.0 1 "rising" nil nil) - cross(VT("/OUT1") 0 1 "rising" nil nil))
plot( Rise\ Delay ?expr '( "Rise Delay" ) )
Falling\ Delay = cross(VT("/OUT1") 0.005 2 "falling" nil nil)
plot( Falling\ Delay ?expr '( "Falling Delay" ) )
modelFile(
    '("/afs/ece.cmu.edu/class/ece320/F10/gpdk090_v4.5/libs.oa22/gpdk090/../../models/spectre/gpdk090.scs" "NN")
)
run()
selectResult( 'tran )
plot(getData("/OUT1") )
Rise\ Delay = (cross(VT("/OUT1") 1.0 1 "rising" nil nil) - cross(VT("/OUT1") 0 1 "rising" nil nil))
plot( Rise\ Delay ?expr '( "Rise Delay" ) )
Falling\ Delay = cross(VT("/OUT1") 0.005 1 "falling" nil nil)
plot( Falling\ Delay ?expr '( "Falling Delay" ) )
modelFile(
    '("/afs/ece.cmu.edu/class/ece320/F10/gpdk090_v4.5/libs.oa22/gpdk090/../../models/spectre/gpdk090.scs" "NN")
)
run()
selectResult( 'tran )
plot(getData("/OUT1") )
Rise\ Delay = (cross(VT("/OUT1") 1.0 1 "rising" nil nil) - cross(VT("/OUT1") 0 1 "rising" nil nil))
plot( Rise\ Delay ?expr '( "Rise Delay" ) )
Falling\ Delay = cross(VT("/OUT1") 1 1 "falling" nil nil)
plot( Falling\ Delay ?expr '( "Falling Delay" ) )
modelFile(
    '("/afs/ece.cmu.edu/class/ece320/F10/gpdk090_v4.5/libs.oa22/gpdk090/../../models/spectre/gpdk090.scs" "NN")
)
run()
selectResult( 'tran )
plot(getData("/OUT1") )
Rise\ Delay = (cross(VT("/OUT1") 1.0 1 "rising" nil nil) - cross(VT("/OUT1") 0 1 "rising" nil nil))
plot( Rise\ Delay ?expr '( "Rise Delay" ) )
Falling\ Delay = cross(VT("/OUT1") 1.2 1 "falling" nil nil)
plot( Falling\ Delay ?expr '( "Falling Delay" ) )
modelFile(
    '("/afs/ece.cmu.edu/class/ece320/F10/gpdk090_v4.5/libs.oa22/gpdk090/../../models/spectre/gpdk090.scs" "NN")
)
run()
selectResult( 'tran )
plot(getData("/OUT1") )
Rise\ Delay = (cross(VT("/OUT1") 1.0 1 "rising" nil nil) - cross(VT("/OUT1") 0 1 "rising" nil nil))
plot( Rise\ Delay ?expr '( "Rise Delay" ) )
Falling\ Delay = (cross(VT("/OUT1") 0.005 1 "falling" nil nil) - cross(VT("/OUT1") 1.2 1 "falling" nil nil))
plot( Falling\ Delay ?expr '( "Falling Delay" ) )
modelFile(
    '("/afs/ece.cmu.edu/class/ece320/F10/gpdk090_v4.5/libs.oa22/gpdk090/../../models/spectre/gpdk090.scs" "NN")
)
run()
selectResult( 'tran )
plot(getData("/D0") getData("/OUT1") )
Rise\ Delay = (cross(VT("/OUT1") 1.0 1 "rising" nil nil) - cross(VT("/OUT1") 0 1 "rising" nil nil))
plot( Rise\ Delay ?expr '( "Rise Delay" ) )
Falling\ Delay = (cross(VT("/OUT1") 0.005 1 "falling" nil nil) - cross(VT("/OUT1") 1.2 1 "falling" nil nil))
plot( Falling\ Delay ?expr '( "Falling Delay" ) )
modelFile(
    '("/afs/ece.cmu.edu/class/ece320/F10/gpdk090_v4.5/libs.oa22/gpdk090/../../models/spectre/gpdk090.scs" "NN")
)
run()
selectResult( 'tran )
plot(getData("/D0") getData("/OUT1") )
Rise\ Delay = (cross(VT("/OUT1") 1.0 1 "rising" nil nil) - cross(VT("/OUT1") 0 1 "rising" nil nil))
plot( Rise\ Delay ?expr '( "Rise Delay" ) )
Falling\ Delay = (cross(VT("/OUT1") 0.005 1 "falling" nil nil) - cross(VT("/OUT1") 1.2 1 "falling" nil nil))
plot( Falling\ Delay ?expr '( "Falling Delay" ) )
Contamination\ Delay = cross(VT("/D0") 1.1 1 "rising" nil nil)
plot( Contamination\ Delay ?expr '( "Contamination Delay" ) )
modelFile(
    '("/afs/ece.cmu.edu/class/ece320/F10/gpdk090_v4.5/libs.oa22/gpdk090/../../models/spectre/gpdk090.scs" "NN")
)
run()
selectResult( 'tran )
plot(getData("/D0") getData("/OUT1") )
Rise\ Delay = (cross(VT("/OUT1") 1.0 1 "rising" nil nil) - cross(VT("/OUT1") 0 1 "rising" nil nil))
plot( Rise\ Delay ?expr '( "Rise Delay" ) )
Falling\ Delay = (cross(VT("/OUT1") 0.005 1 "falling" nil nil) - cross(VT("/OUT1") 1.2 1 "falling" nil nil))
plot( Falling\ Delay ?expr '( "Falling Delay" ) )
Contamination\ Delay = cross(VT("/D0") 1.19 1 "rising" nil nil)
plot( Contamination\ Delay ?expr '( "Contamination Delay" ) )
modelFile(
    '("/afs/ece.cmu.edu/class/ece320/F10/gpdk090_v4.5/libs.oa22/gpdk090/../../models/spectre/gpdk090.scs" "NN")
)
run()
selectResult( 'tran )
plot(getData("/D0") getData("/OUT1") )
Rise\ Delay = (cross(VT("/OUT1") 1.0 1 "rising" nil nil) - cross(VT("/OUT1") 0 1 "rising" nil nil))
plot( Rise\ Delay ?expr '( "Rise Delay" ) )
Falling\ Delay = (cross(VT("/OUT1") 0.005 1 "falling" nil nil) - cross(VT("/OUT1") 1.2 1 "falling" nil nil))
plot( Falling\ Delay ?expr '( "Falling Delay" ) )
Contamination\ Delay = cross(VT("/OUT1") 1.19 1 "rising" nil nil)
plot( Contamination\ Delay ?expr '( "Contamination Delay" ) )
modelFile(
    '("/afs/ece.cmu.edu/class/ece320/F10/gpdk090_v4.5/libs.oa22/gpdk090/../../models/spectre/gpdk090.scs" "NN")
)
run()
selectResult( 'tran )
plot(getData("/D0") getData("/OUT1") )
Rise\ Delay = (cross(VT("/OUT1") 1.0 1 "rising" nil nil) - cross(VT("/OUT1") 0 1 "rising" nil nil))
plot( Rise\ Delay ?expr '( "Rise Delay" ) )
Falling\ Delay = (cross(VT("/OUT1") 0.005 1 "falling" nil nil) - cross(VT("/OUT1") 1.2 1 "falling" nil nil))
plot( Falling\ Delay ?expr '( "Falling Delay" ) )
Contamination\ Delay = (cross(VT("/OUT1") 1.19 1 "falling" nil nil) - cross(VT("/D0") 0.005 1 "falling" nil nil))
plot( Contamination\ Delay ?expr '( "Contamination Delay" ) )
modelFile(
    '("/afs/ece.cmu.edu/class/ece320/F10/gpdk090_v4.5/libs.oa22/gpdk090/../../models/spectre/gpdk090.scs" "NN")
)
run()
selectResult( 'tran )
plot(getData("/D0") getData("/OUT1") )
Rise\ Delay = (cross(VT("/OUT1") 1.0 1 "rising" nil nil) - cross(VT("/OUT1") 0 1 "rising" nil nil))
plot( Rise\ Delay ?expr '( "Rise Delay" ) )
Falling\ Delay = (cross(VT("/OUT1") 0.005 1 "falling" nil nil) - cross(VT("/OUT1") 1.2 1 "falling" nil nil))
plot( Falling\ Delay ?expr '( "Falling Delay" ) )
Contamination\ Delay = cross(VT("/OUT1") 1.19 1 "falling" nil nil)
plot( Contamination\ Delay ?expr '( "Contamination Delay" ) )
modelFile(
    '("/afs/ece.cmu.edu/class/ece320/F10/gpdk090_v4.5/libs.oa22/gpdk090/../../models/spectre/gpdk090.scs" "NN")
)
run()
selectResult( 'tran )
plot(getData("/D0") getData("/OUT1") )
Rise\ Delay = (cross(VT("/OUT1") 1.0 1 "rising" nil nil) - cross(VT("/OUT1") 0 1 "rising" nil nil))
plot( Rise\ Delay ?expr '( "Rise Delay" ) )
Falling\ Delay = (cross(VT("/OUT1") 0.005 1 "falling" nil nil) - cross(VT("/OUT1") 1.2 1 "falling" nil nil))
plot( Falling\ Delay ?expr '( "Falling Delay" ) )
Contamination\ Delay = cross(VT("/D0") 0.005 1 "falling" nil nil)
plot( Contamination\ Delay ?expr '( "Contamination Delay" ) )
modelFile(
    '("/afs/ece.cmu.edu/class/ece320/F10/gpdk090_v4.5/libs.oa22/gpdk090/../../models/spectre/gpdk090.scs" "NN")
)
run()
selectResult( 'tran )
plot(getData("/D0") getData("/OUT1") )
Rise\ Delay = (cross(VT("/OUT1") 1.0 1 "rising" nil nil) - cross(VT("/OUT1") 0 1 "rising" nil nil))
plot( Rise\ Delay ?expr '( "Rise Delay" ) )
Falling\ Delay = (cross(VT("/OUT1") 0.005 1 "falling" nil nil) - cross(VT("/OUT1") 1.2 1 "falling" nil nil))
plot( Falling\ Delay ?expr '( "Falling Delay" ) )
Contamination\ Delay = (cross(VT("/D0") 0.005 1 "falling" nil nil) - cross(VT("/OUT1") 1.19 1 "falling" nil nil))
plot( Contamination\ Delay ?expr '( "Contamination Delay" ) )

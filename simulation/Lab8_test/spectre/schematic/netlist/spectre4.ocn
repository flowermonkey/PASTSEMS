simulator( 'spectre )
design(	 "/afs/ece.cmu.edu/usr/bflores/simulation/Lab8_test/spectre/schematic/netlist/netlist")
resultsDir( "/afs/ece.cmu.edu/usr/bflores/simulation/Lab8_test/spectre/schematic" )
modelFile(
    '("/afs/ece.cmu.edu/class/ece320/F10/gpdk090_v4.5/libs.oa22/gpdk090/../../models/spectre/gpdk090.scs" "NN")
)
analysis('tran ?stop "5n"  )
desVar(	  "lambda" 50n	)
desVar(	  "beta" 2.5	)
save( 'i "/V2/PLUS" )
temp( 27 )
run()
selectResult( 'tran )
plot(getData("/in") getData("/V2/PLUS") getData("/out") )
AVG\ PWR\ DISS = (integ((IT * ("/V2/PLUS") * VT("/vdd")) 0 5e-09) * (1 / (5e-09)))
plot( AVG\ PWR\ DISS ?expr '( "AVG PWR DISS" ) )
modelFile(
    '("/afs/ece.cmu.edu/class/ece320/F10/gpdk090_v4.5/libs.oa22/gpdk090/../../models/spectre/gpdk090.scs" "NN")
)
run()
selectResult( 'tran )
plot(getData("/in") getData("/out") )
AVG\ PWR\ DISS = (integ((IT * ("/V2/PLUS") * VT("/vdd")) 0 5e-09) * (1 / (5e-09)))
plot( AVG\ PWR\ DISS ?expr '( "AVG PWR DISS" ) )
modelFile(
    '("/afs/ece.cmu.edu/class/ece320/F10/gpdk090_v4.5/libs.oa22/gpdk090/../../models/spectre/gpdk090.scs" "NN")
)
save( 'i /V2/PLUS )
run()
selectResult( 'tran )
plot(getData("/in") getData("/out") )
AVG\ PWR\ DISS = (integ((IT * ("/V2/PLUS") * VT("/vdd")) 0 5e-09) * (1 / (5e-09)))
plot( AVG\ PWR\ DISS ?expr '( "AVG PWR DISS" ) )
modelFile(
    '("/afs/ece.cmu.edu/class/ece320/F10/gpdk090_v4.5/libs.oa22/gpdk090/../../models/spectre/gpdk090.scs" "NN")
)
save( 'i "/V2/PLUS" )
run()
selectResult( 'tran )
plot(getData("/in") getData("/out") )
AVG\ PWR\ DISS = (integ((IT("/V2/PLUS") * VT("/vdd")) 0 5e-09) * (1 / (5e-09)))
plot( AVG\ PWR\ DISS ?expr '( "AVG PWR DISS" ) )
modelFile(
    '("/afs/ece.cmu.edu/class/ece320/F10/gpdk090_v4.5/libs.oa22/gpdk090/../../models/spectre/gpdk090.scs" "NN")
)
run()
selectResult( 'tran )
plot(getData("/in") getData("/out") )
AVG\ PWR\ DISS = (integ(IT("/V2/PLUS") 0 5e-09) * (1.2 / 5e-09))
plot( AVG\ PWR\ DISS ?expr '( "AVG PWR DISS" ) )
modelFile(
    '("/afs/ece.cmu.edu/class/ece320/F10/gpdk090_v4.5/libs.oa22/gpdk090/../../models/spectre/gpdk090.scs" "NN")
)
run()
selectResult( 'tran )
plot(getData("/in") getData("/out") )
AVG\ PWR\ DISS = (integ(IT("/V2/PLUS") 0 5e-09) * (1.2 / 5e-09))
plot( AVG\ PWR\ DISS ?expr '( "AVG PWR DISS" ) )
modelFile(
    '("/afs/ece.cmu.edu/class/ece320/F10/gpdk090_v4.5/libs.oa22/gpdk090/../../models/spectre/gpdk090.scs" "NN")
)
run()
selectResult( 'tran )
plot(getData("/I0/I5/B") getData("/I0/I5/A") getData("/I0/I5/OUT") )

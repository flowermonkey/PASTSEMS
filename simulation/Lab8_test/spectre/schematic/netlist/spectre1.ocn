simulator( 'spectre )
design(	 "/afs/ece.cmu.edu/usr/bflores/simulation/Lab8_test/spectre/schematic/netlist/netlist")
resultsDir( "/afs/ece.cmu.edu/usr/bflores/simulation/Lab8_test/spectre/schematic" )
modelFile(
    '("/afs/ece.cmu.edu/class/ece320/F10/gpdk090_v4.5/libs.oa22/gpdk090/../../models/spectre/gpdk090.scs" "NN")
)
temp( 27 )
run()
modelFile(
    '("/afs/ece.cmu.edu/class/ece320/F10/gpdk090_v4.5/libs.oa22/gpdk090/../../models/spectre/gpdk090.scs" "NN")
)
desVar(	  "lambda" 50n	)
desVar(	  "beta" 2.5	)
run()
modelFile(
    '("/afs/ece.cmu.edu/class/ece320/F10/gpdk090_v4.5/libs.oa22/gpdk090/../../models/spectre/gpdk090.scs" "NN")
)
run()
modelFile(
    '("/afs/ece.cmu.edu/class/ece320/F10/gpdk090_v4.5/libs.oa22/gpdk090/../../models/spectre/gpdk090.scs" "NN")
)
run()
modelFile(
    '("/afs/ece.cmu.edu/class/ece320/F10/gpdk090_v4.5/libs.oa22/gpdk090/../../models/spectre/gpdk090.scs" "NN")
)
save( 'i "/V2/MINUS" "/V2/PLUS" )
run()
modelFile(
    '("/afs/ece.cmu.edu/class/ece320/F10/gpdk090_v4.5/libs.oa22/gpdk090/../../models/spectre/gpdk090.scs" "NN")
)
save( 'i /V2/MINUS /V2/PLUS )
run()
modelFile(
    '("/afs/ece.cmu.edu/class/ece320/F10/gpdk090_v4.5/libs.oa22/gpdk090/../../models/spectre/gpdk090.scs" "NN")
)
run()
modelFile(
    '("/afs/ece.cmu.edu/class/ece320/F10/gpdk090_v4.5/libs.oa22/gpdk090/../../models/spectre/gpdk090.scs" "NN")
)
run()
plot( delay(VT("/in") 2.5 1 "either" VT("/out") 2.5 1 "either" 0 0 nil nil) )
modelFile(
    '("/afs/ece.cmu.edu/class/ece320/F10/gpdk090_v4.5/libs.oa22/gpdk090/../../models/spectre/gpdk090.scs" "NN")
)
run()
plot( delay(VT("/in") 2.5 1 "either" VT("/out") 2.5 1 "either" 0 0 nil nil) )
modelFile(
    '("/afs/ece.cmu.edu/class/ece320/F10/gpdk090_v4.5/libs.oa22/gpdk090/../../models/spectre/gpdk090.scs" "NN")
)
run()
modelFile(
    '("/afs/ece.cmu.edu/class/ece320/F10/gpdk090_v4.5/libs.oa22/gpdk090/../../models/spectre/gpdk090.scs" "NN")
)
run()
modelFile(
    '("/afs/ece.cmu.edu/class/ece320/F10/gpdk090_v4.5/libs.oa22/gpdk090/../../models/spectre/gpdk090.scs" "NN")
)
run()
modelFile(
    '("/afs/ece.cmu.edu/class/ece320/F10/gpdk090_v4.5/libs.oa22/gpdk090/../../models/spectre/gpdk090.scs" "NN")
)
run()
modelFile(
    '("/afs/ece.cmu.edu/class/ece320/F10/gpdk090_v4.5/libs.oa22/gpdk090/../../models/spectre/gpdk090.scs" "NN")
)
run()
modelFile(
    '("/afs/ece.cmu.edu/class/ece320/F10/gpdk090_v4.5/libs.oa22/gpdk090/../../models/spectre/gpdk090.scs" "NN")
)
analysis('tran ?stop "5n"  )
run()
selectResult( 'tran )
plot(getData("/out") )
modelFile(
    '("/afs/ece.cmu.edu/class/ece320/F10/gpdk090_v4.5/libs.oa22/gpdk090/../../models/spectre/gpdk090.scs" "NN")
)
run()
selectResult( 'tran )
plot(getData("/in") getData("/out") )
modelFile(
    '("/afs/ece.cmu.edu/class/ece320/F10/gpdk090_v4.5/libs.oa22/gpdk090/../../models/spectre/gpdk090.scs" "NN")
)
run()
selectResult( 'tran )
plot(getData("/in") getData("/out") )
plot( delay(VT("/in") 2.5 1 "either" VT("/out") 2.5 1 "either" 0 0 nil nil) )
modelFile(
    '("/afs/ece.cmu.edu/class/ece320/F10/gpdk090_v4.5/libs.oa22/gpdk090/../../models/spectre/gpdk090.scs" "NN")
)
run()
selectResult( 'tran )
plot(getData("/in") getData("/out") )
plot( delay(VT("/in") 2.5 1 "either" VT("/out") 2.5 1 "either" 0 0 nil nil) )
modelFile(
    '("/afs/ece.cmu.edu/class/ece320/F10/gpdk090_v4.5/libs.oa22/gpdk090/../../models/spectre/gpdk090.scs" "NN")
)
run()
selectResult( 'tran )
plot(getData("/in") getData("/out") )
delay = delay(VT("/in") 2.5 1 "either" VT("/out") 2.5 1 "either" 0 0 nil nil)
plot( delay ?expr '( "delay" ) )
modelFile(
    '("/afs/ece.cmu.edu/class/ece320/F10/gpdk090_v4.5/libs.oa22/gpdk090/../../models/spectre/gpdk090.scs" "NN")
)
run()
selectResult( 'tran )
plot(getData("/in") getData("/out") )
delay = delay(VT("/in") 2.5 1 "either" VT("/out") 2.5 1 "either" 0 0 nil nil)
plot( delay ?expr '( "delay" ) )
modelFile(
    '("/afs/ece.cmu.edu/class/ece320/F10/gpdk090_v4.5/libs.oa22/gpdk090/../../models/spectre/gpdk090.scs" "NN")
)
run()
selectResult( 'tran )
plot(getData("/in") getData("/out") )
delay = delay(VT("/out") 0.6 1 "either" VT("/in") 0.6 1 "either" 0 0 nil nil)
plot( delay ?expr '( "delay" ) )
modelFile(
    '("/afs/ece.cmu.edu/class/ece320/F10/gpdk090_v4.5/libs.oa22/gpdk090/../../models/spectre/gpdk090.scs" "NN")
)
run()
selectResult( 'tran )
plot(getData("/in") getData("/out") )
delay = delay(VT("/out") 0.6 1 "either" VT("/in") 0.6 1 "either" 0 0 nil nil)
plot( delay ?expr '( "delay" ) )
modelFile(
    '("/afs/ece.cmu.edu/class/ece320/F10/gpdk090_v4.5/libs.oa22/gpdk090/../../models/spectre/gpdk090.scs" "NN")
)
run()
selectResult( 'tran )
plot(getData("/in") getData("/out") )
delay = delay(VT("/out") 0.6 1 "either" VT("/in") 0.6 1 "either" 0 0 nil nil)
plot( delay ?expr '( "delay" ) )

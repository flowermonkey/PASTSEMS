simulator( 'spectre )
design(	 "/afs/ece.cmu.edu/usr/bflores/simulation/Lab8_test/spectre/schematic/netlist/netlist")
resultsDir( "/afs/ece.cmu.edu/usr/bflores/simulation/Lab8_test/spectre/schematic" )
modelFile(
    '("/afs/ece.cmu.edu/class/ece320/F10/gpdk090_v4.5/libs.oa22/gpdk090/../../models/spectre/gpdk090.scs" "NN")
)
analysis('tran ?stop "5n"  )
desVar(	  "lambda" 50n	)
desVar(	  "beta" 2.5	)
save( 'i "/I0/I5/B" "/I0/I5/A" "/I0/I5/OUT" )
temp( 27 )
run()
selectResult( 'tran )
plot(getData("/I0/I5/B") getData("/I0/I5/A") getData("/I0/I5/OUT") )
modelFile(
    '("/afs/ece.cmu.edu/class/ece320/F10/gpdk090_v4.5/libs.oa22/gpdk090/../../models/spectre/gpdk090.scs" "NN")
)
save( 'i /I0/I5/B /I0/I5/A /I0/I5/OUT )
run()
selectResult( 'tran )
plot(getData("/in") getData("/I0/net044") getData("/I0/net055") )
modelFile(
    '("/afs/ece.cmu.edu/class/ece320/F10/gpdk090_v4.5/libs.oa22/gpdk090/../../models/spectre/gpdk090.scs" "NN")
)
run()
selectResult( 'tran )
plot(getData("/I0/net044") getData("/I0/net055") getData("/in") )

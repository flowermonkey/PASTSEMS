ADE simulation setup
Run mode: Single Run, Sweeps and Corners
Tests:
  Lab8:Lab8_test:1: Lab8/Lab8_test/schematic, simulator spectre
Global variables:
  beta = 2.5
  lambda = 50n

ADE simulation setup
Run mode: Single Run, Sweeps and Corners
Tests:
  lab9:l9_testbench:1: lab9/l9_testbench/schematic, simulator spectre
Global variables:
  beta = 2.52
  lambda = 50n

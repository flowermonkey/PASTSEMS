ADE simulation setup
Run mode: Single Run, Sweeps and Corners
Tests:
  lab9:test2:1: lab9/test2/schematic, simulator spectre
Global variables:
  beta = 2
